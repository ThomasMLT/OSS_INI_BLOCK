** sch_path: /foss/designs/ihp_INI_project/xschem_ttihp26a_update_adapt/neuron.sch
.subckt neuron vdda DPI_gain_VNI DPI_lk_VNI SOM_mem_VTO req_VAO ADAP_gain_VPI ADAPDPI_gain_VNI ADAPDPI_cap_VTO ack_VAI
+ ADAPDPI_lk_VNI REF_lk_VNI vssa REF_cap_VTO PULEXT_pwbias_VPI DPI_in_UNI
*.PININFO REF_lk_VNI:I vssa:B vdda:B req_VAO:O ack_VAI:I DPI_lk_VNI:I ADAP_gain_VPI:I ADAPDPI_gain_VNI:I ADAPDPI_lk_VNI:I
*+ ADAPDPI_cap_VTO:O SOM_mem_VTO:O REF_cap_VTO:O PULEXT_pwbias_VPI:I DPI_gain_VNI:I DPI_in_UNI:B
Xfb vdda FB_cmpstate_VABO SOM_mem_VTO vssa FB_system
Xadap vdda PULEXT_ackext_VABO ADAPDPI_cap_VTO ADAP_gain_VPI DPI_in_UNI ADAPDPI_gain_VNI ADAPDPI_lk_VNI vssa ADAP_system
Xref net2 SOM_mem_VTO net1 REF_cap_VTO vssa REF_lk_VNI vdda REF_system
xext vdda vssa net3 ack_VAI PULEXT_pwbias_VPI PULEXT_cap_VP pulse_extender_V2
Xinv2 vdda net1 req_VAO vssa inv
Xinv3 vdda net2 ack_VAI vssa inv
Xinv4 vdda PULEXT_ackext_VABO net3 vssa inv
CC6 SOM_mem_VTO vssa SOM_mem_VTO vssa sg13_hv_svaricap w=9.74u l=0.8u Nx=3
CC7 SOM_mem_VTO vssa SOM_mem_VTO vssa sg13_hv_svaricap w=9.74u l=0.8u Nx=3
CC4 PULEXT_cap_VP vssa PULEXT_cap_VP vssa sg13_hv_svaricap w=3.74u l=0.3u Nx=1
x1 vdda req_VAO FB_cmpstate_VABO vssa inv_hc
Xdpi1 DPI_in_UNI vdda SOM_mem_VTO DPI_gain_VNI vssa DPI_lk_VNI DPI_gain
CC1 SOM_mem_VTO vssa SOM_mem_VTO vssa sg13_hv_svaricap w=9.74u l=0.8u Nx=3
CC5 SOM_mem_VTO vssa SOM_mem_VTO vssa sg13_hv_svaricap w=9.74u l=0.8u Nx=3
CC8 SOM_mem_VTO vssa SOM_mem_VTO vssa sg13_hv_svaricap w=9.74u l=0.8u Nx=3
CC9 ADAPDPI_cap_VTO vssa ADAPDPI_cap_VTO vssa sg13_hv_svaricap w=9.74u l=0.8u Nx=3
CC10 ADAPDPI_cap_VTO vssa ADAPDPI_cap_VTO vssa sg13_hv_svaricap w=9.74u l=0.8u Nx=3
CC11 ADAPDPI_cap_VTO vssa ADAPDPI_cap_VTO vssa sg13_hv_svaricap w=9.74u l=0.8u Nx=3
CC2 REF_cap_VTO vssa REF_cap_VTO vssa sg13_hv_svaricap w=9.74u l=0.8u Nx=3
CC3 REF_cap_VTO vssa REF_cap_VTO vssa sg13_hv_svaricap w=9.74u l=0.8u Nx=3
CC12 REF_cap_VTO vssa REF_cap_VTO vssa sg13_hv_svaricap w=9.74u l=0.8u Nx=3
.ends

* expanding   symbol:  FB_system.sym # of pins=4
** sym_path: /foss/designs/ihp_INI_project/xschem_ttihp26a_update_adapt/FB_system.sym
** sch_path: /foss/designs/ihp_INI_project/xschem_ttihp26a_update_adapt/FB_system.sch
.subckt FB_system vdda out V_mem vssa
*.PININFO out:O V_mem:B vssa:B vdda:B
MMmirr Vmir Vmir vdda vdda sg13_hv_pmos w=4u l=2u ng=4
MMmirl4 V_mem Vmir net1 vdda sg13_hv_pmos w=1u l=2u ng=1
MMthr out V_mem Vmir vdda sg13_hv_pmos w=4u l=2u ng=4
MMmem1 out V_mem net2 vssa sg13_hv_nmos w=1u l=2u ng=1 m=2
MMmirl3 net1 Vmir net3 vdda sg13_hv_pmos w=1u l=2u ng=1
MMmirl2 net3 Vmir net4 vdda sg13_hv_pmos w=1u l=2u ng=1
MMmirl1 net4 Vmir vdda vdda sg13_hv_pmos w=1u l=2u ng=1
MMmem2 net2 V_mem net5 vssa sg13_hv_nmos w=1u l=2u ng=1 m=2
MMmem3 net5 V_mem net6 vssa sg13_hv_nmos w=1u l=2u ng=1 m=2
MMmem4 net6 V_mem vssa vssa sg13_hv_nmos w=1u l=2u ng=1 m=2
MMdum6 out vdda vdda vdda sg13_hv_pmos w=1u l=2u ng=1 m=2
MMdum7 V_mem vdda vdda vdda sg13_hv_pmos w=1u l=2u ng=1
MMdum1 vssa vssa out vssa sg13_hv_nmos w=2u l=2u ng=2
.ends

* expanding   symbol:  ADAP_system.sym # of pins=8
** sym_path: /foss/designs/ihp_INI_project/xschem_ttihp26a_update_adapt/ADAP_system.sym
** sch_path: /foss/designs/ihp_INI_project/xschem_ttihp26a_update_adapt/ADAP_system.sch
.subckt ADAP_system vdda ackext_VABI DPI_capabias_VP gain_VPI in_UNO DPI_gain_VNI DPI_lk_VNI vssa
*.PININFO ackext_VABI:I gain_VPI:I DPI_gain_VNI:I DPI_lk_VNI:I vssa:B vdda:B DPI_capabias_VP:B in_UNO:B
MM21 net1 gain_VPI net_DM1_SM21 vdda sg13_hv_pmos w=4u l=4u ng=2 m=4
MM18 in_UNO DPI_capabias_VP vssa vssa sg13_hv_nmos w=4u l=4u ng=2 m=4
MM1 net_DM1_SM21 ackext_VABI vdda vdda sg13_hv_pmos w=1.2u l=4u ng=4
Xdpi2 net1 vdda DPI_capabias_VP DPI_gain_VNI vssa DPI_lk_VNI DPI_gain
MMdum5 net_DM1_SM21 vdda vdda vdda sg13_hv_pmos w=8.6u l=2.75u ng=1
.ends

* expanding   symbol:  REF_system.sym # of pins=7
** sym_path: /foss/designs/ihp_INI_project/xschem_ttihp26a_update_adapt/REF_system.sym
** sch_path: /foss/designs/ihp_INI_project/xschem_ttihp26a_update_adapt/REF_system.sch
.subckt REF_system ack_VABI mem_VNO req_VABI capabias_VPN vssa lk_VPI vdda
*.PININFO lk_VPI:I req_VABI:I ack_VABI:I capabias_VPN:B mem_VNO:O vssa:B vdda:B
MM10 capabias_VPN req_VABI net2 vdda sg13_hv_pmos w=1u l=0.5u ng=1
MM11 capabias_VPN req_VABI net1 vssa sg13_hv_nmos w=1u l=0.5u ng=1
MM12 net2 ack_VABI vdda vdda sg13_hv_pmos w=1u l=0.5u ng=1
MM13 mem_VNO capabias_VPN vssa vssa sg13_hv_nmos w=1u l=0.5u ng=1
MM14 net1 lk_VPI vssa vssa sg13_hv_nmos w=4u l=4u ng=2 m=4
.ends

* expanding   symbol:  pulse_extender_V2.sym # of pins=6
** sym_path: /foss/designs/ihp_INI_project/xschem_ttihp26a_update_adapt/pulse_extender_V2.sym
** sch_path: /foss/designs/ihp_INI_project/xschem_ttihp26a_update_adapt/pulse_extender_V2.sch
.subckt pulse_extender_V2 vdda vssa out_VAO in_VAI pwbias_VPI capa_VP
*.PININFO out_VAO:O pwbias_VPI:I in_VAI:I capa_VP:B vssa:B vdda:B
MMp1 out_VAO capa_VP vdda vdda sg13_hv_pmos w=4u l=2u ng=1
MMn1 out_VAO capa_VP vssa vssa sg13_hv_nmos w=4u l=2u ng=1
MMn4 capa_VP in_VAI vssa vssa sg13_hv_nmos w=4u l=2u ng=1
MMstarve4 capa_VP pwbias_VPI vdda vdda sg13_hv_pmos w=4u l=2u ng=1
MMp3 capa_VP out_VAO vdda vdda sg13_hv_pmos w=4u l=2u ng=1
.ends

* expanding   symbol:  inv.sym # of pins=4
** sym_path: /foss/designs/ihp_INI_project/xschem_ttihp26a_update_adapt/inv.sym
** sch_path: /foss/designs/ihp_INI_project/xschem_ttihp26a_update_adapt/inv.sch
.subckt inv vdda out in vssa
*.PININFO in:I out:O vssa:B vdda:B
MM1 out in vdda vdda sg13_hv_pmos w=4u l=0.5u ng=1
MM2 out in vssa vssa sg13_hv_nmos w=4u l=0.5u ng=1
.ends

* expanding   symbol:  inv_hc.sym # of pins=4
** sym_path: /foss/designs/ihp_INI_project/xschem_ttihp26a_update_adapt/inv_hc.sym
** sch_path: /foss/designs/ihp_INI_project/xschem_ttihp26a_update_adapt/inv_hc.sch
.subckt inv_hc vdda out in vssa
*.PININFO in:I out:O vssa:B vdda:B
MM1 out in vdda vdda sg13_hv_pmos w=10u l=0.5u ng=1
MM2 out in vssa vssa sg13_hv_nmos w=10u l=0.5u ng=1
.ends

* expanding   symbol:  DPI_gain.sym # of pins=6
** sym_path: /foss/designs/ihp_INI_project/xschem_ttihp26a_update_adapt/DPI_gain.sym
** sch_path: /foss/designs/ihp_INI_project/xschem_ttihp26a_update_adapt/DPI_gain.sch
.subckt DPI_gain in_UI vdda capabias_VPN gain_VNI vssa lk_VNI
*.PININFO gain_VNI:I lk_VNI:I capabias_VPN:B vssa:B vdda:B in_UI:B
MMdifl vssa gain_VNI in_UI vdda sg13_hv_pmos w=2u l=2u ng=2 m=8
MMdifr capabias_VPN capabias_VPN in_UI vdda sg13_hv_pmos w=2u l=2u ng=2 m=8
MMtau capabias_VPN lk_VNI vssa vssa sg13_hv_nmos w=4u l=4u ng=2 m=4
MMdum2 in_UI vdda vdda vdda sg13_hv_pmos w=1u l=2u ng=1 m=8
.ends
