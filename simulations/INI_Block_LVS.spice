** sch_path: /foss/designs/ihp_INI_project/INI_Block/INI_Block_LVS.sch
.subckt INI_Block_LVS NNDPI_lk_VNI NNDPI_gain_VNI VSS VDD V2I_imax_VPI NN1_REQ NN1_ACK NN1_MEM_PROB V2I_INN V2I_INP
+ BIASGEN_en_VS[10] BIASGEN_en_VS[9] BIASGEN_en_VS[8] BIASGEN_en_VS[7] BIASGEN_en_VS[6] BIASGEN_en_VS[5] BIASGEN_en_VS[4] BIASGEN_en_VS[3]
+ BIASGEN_en_VS[2] BIASGEN_en_VS[1] BIASGEN_BYP_en_VS[10] BIASGEN_BYP_en_VS[9] BIASGEN_BYP_en_VS[8] BIASGEN_BYP_en_VS[7] BIASGEN_BYP_en_VS[6]
+ BIASGEN_BYP_en_VS[5] BIASGEN_BYP_en_VS[4] BIASGEN_BYP_en_VS[3] BIASGEN_BYP_en_VS[2] BIASGEN_BYP_en_VS[1] BIASGEN_EXT_REF_en_VS[10]
+ BIASGEN_EXT_REF_en_VS[9] BIASGEN_EXT_REF_en_VS[8] BIASGEN_EXT_REF_en_VS[7] BIASGEN_EXT_REF_en_VS[6] BIASGEN_EXT_REF_en_VS[5] BIASGEN_EXT_REF_en_VS[4]
+ BIASGEN_EXT_REF_en_VS[3] BIASGEN_EXT_REF_en_VS[2] BIASGEN_EXT_REF_en_VS[1] C2F_en_VSBI[10] C2F_en_VSBI[9] C2F_en_VSBI[8] C2F_en_VSBI[7] C2F_en_VSBI[6]
+ C2F_en_VSBI[5] C2F_en_VSBI[4] C2F_en_VSBI[3] C2F_en_VSBI[2] C2F_en_VSBI[1] en_VS_9[10] en_VS_9[9] en_VS_9[8] en_VS_9[7] en_VS_9[6] en_VS_9[5]
+ en_VS_9[4] en_VS_9[3] en_VS_9[2] en_VS_9[1] en_VS_9[0] C2F_Vb BIASGEN_en_VS ref_VUN[7] ref_VUN[6] ref_VUN[5] ref_VUN[4] ref_VUN[3]
+ ref_VUN[2] ref_VUN[1] ref_VUN[0] en_VS_8[10] en_VS_8[9] en_VS_8[8] en_VS_8[7] en_VS_8[6] en_VS_8[5] en_VS_8[4] en_VS_8[3] en_VS_8[2]
+ en_VS_8[1] en_VS_8[0] en_VS_7[10] en_VS_7[9] en_VS_7[8] en_VS_7[7] en_VS_7[6] en_VS_7[5] en_VS_7[4] en_VS_7[3] en_VS_7[2] en_VS_7[1]
+ en_VS_7[0] en_VS_6[10] en_VS_6[9] en_VS_6[8] en_VS_6[7] en_VS_6[6] en_VS_6[5] en_VS_6[4] en_VS_6[3] en_VS_6[2] en_VS_6[1] en_VS_6[0]
+ en_VS_5[10] en_VS_5[9] en_VS_5[8] en_VS_5[7] en_VS_5[6] en_VS_5[5] en_VS_5[4] en_VS_5[3] en_VS_5[2] en_VS_5[1] en_VS_5[0] en_VS_4[10]
+ en_VS_4[9] en_VS_4[8] en_VS_4[7] en_VS_4[6] en_VS_4[5] en_VS_4[4] en_VS_4[3] en_VS_4[2] en_VS_4[1] en_VS_4[0]
*.PININFO NNDPI_lk_VNI:I NNDPI_gain_VNI:I VSS:I VDD:I V2I_imax_VPI:I NN1_REQ:O NN1_ACK:I NN1_MEM_PROB:O V2I_INN:I V2I_INP:I
*+ BIASGEN_en_VS[10:1]:I BIASGEN_BYP_en_VS[10:1]:I BIASGEN_EXT_REF_en_VS[10:1]:I C2F_en_VSBI[10:1]:I en_VS_9[10:0]:I C2F_Vb:O BIASGEN_en_VS:I
*+ ref_VUN[7:0]:I en_VS_8[10:0]:I en_VS_7[10:0]:I en_VS_6[10:0]:I en_VS_5[10:0]:I en_VS_4[10:0]:I
x15 VDD NNDPI_gain_VNI NNDPI_lk_VNI NN1_MEM_PROB NN1_REQ NNADAP_gain_VPI NNADAPDPI_gain_VNI NN1_ADAP_cap_VTO NN1_ACK
+ NNADAPDPI_lk_VNI NNREF_lk_VNI VSS NN1_REF_cap_VTO NNPULEXT_pwbias_VPI net1 neuron_LVS
x16 VDD V2I_imax_VPI V2I_INN V2I_INP net1 VSS V2I
* noconn BIASGEN_en_VS[10:1]
* noconn BIASGEN_BYP_en_VS[10:1]
* noconn BIASGEN_EXT_REF_en_VS[10:1]
* noconn C2F_en_VSBI[10:1]
x17 en_VS_9[10] en_VS_9[9] en_VS_9[8] en_VS_9[7] en_VS_9[6] en_VS_9[5] en_VS_9[4] en_VS_9[3] en_VS_9[2] en_VS_9[1] en_VS_9[0] VSS
+ VDD C2F_Vb net2 ref_VUN[7] ref_VUN[6] ref_VUN[5] ref_VUN[4] ref_VUN[3] ref_VUN[2] ref_VUN[1] ref_VUN[0] BIASGEN_en_VS CoreFineDAC_N
* noconn #net2
x1 ref_VUN[7] ref_VUN[6] ref_VUN[5] ref_VUN[4] ref_VUN[3] ref_VUN[2] ref_VUN[1] ref_VUN[0] VSS BIASGEN_en_VS CoreDiodeT
x2 en_VS_8[10] en_VS_8[9] en_VS_8[8] en_VS_8[7] en_VS_8[6] en_VS_8[5] en_VS_8[4] en_VS_8[3] en_VS_8[2] en_VS_8[1] en_VS_8[0] VSS
+ VDD NNPULEXT_pwbias_VPI net3 ref_VUN[7] ref_VUN[6] ref_VUN[5] ref_VUN[4] ref_VUN[3] ref_VUN[2] ref_VUN[1] ref_VUN[0] BIASGEN_en_VS
+ CoreFineDAC_N
* noconn #net3
x10 en_VS_7[10] en_VS_7[9] en_VS_7[8] en_VS_7[7] en_VS_7[6] en_VS_7[5] en_VS_7[4] en_VS_7[3] en_VS_7[2] en_VS_7[1] en_VS_7[0] VSS
+ VDD net4 NNADAPDPI_lk_VNI ref_VUN[7] ref_VUN[6] ref_VUN[5] ref_VUN[4] ref_VUN[3] ref_VUN[2] ref_VUN[1] ref_VUN[0] BIASGEN_en_VS
+ CoreFineDAC_N
* noconn #net4
x9 en_VS_6[10] en_VS_6[9] en_VS_6[8] en_VS_6[7] en_VS_6[6] en_VS_6[5] en_VS_6[4] en_VS_6[3] en_VS_6[2] en_VS_6[1] en_VS_6[0] VSS
+ VDD net5 NNADAPDPI_gain_VNI ref_VUN[7] ref_VUN[6] ref_VUN[5] ref_VUN[4] ref_VUN[3] ref_VUN[2] ref_VUN[1] ref_VUN[0] BIASGEN_en_VS
+ CoreFineDAC_N
* noconn #net5
x8 en_VS_5[10] en_VS_5[9] en_VS_5[8] en_VS_5[7] en_VS_5[6] en_VS_5[5] en_VS_5[4] en_VS_5[3] en_VS_5[2] en_VS_5[1] en_VS_5[0] VSS
+ VDD NNADAP_gain_VPI net6 ref_VUN[7] ref_VUN[6] ref_VUN[5] ref_VUN[4] ref_VUN[3] ref_VUN[2] ref_VUN[1] ref_VUN[0] BIASGEN_en_VS
+ CoreFineDAC_N
* noconn #net6
x7 en_VS_4[10] en_VS_4[9] en_VS_4[8] en_VS_4[7] en_VS_4[6] en_VS_4[5] en_VS_4[4] en_VS_4[3] en_VS_4[2] en_VS_4[1] en_VS_4[0] VSS
+ VDD net7 NNREF_lk_VNI ref_VUN[7] ref_VUN[6] ref_VUN[5] ref_VUN[4] ref_VUN[3] ref_VUN[2] ref_VUN[1] ref_VUN[0] BIASGEN_en_VS
+ CoreFineDAC_N
* noconn #net7
.ends

* expanding   symbol:  neuron_LVS.sym # of pins=15
** sym_path: /foss/designs/ihp_INI_project/INI_Block/neuron_LVS.sym
** sch_path: /foss/designs/ihp_INI_project/INI_Block/neuron_LVS.sch
.subckt neuron_LVS vdda DPI_gain_VNI DPI_lk_VNI SOM_mem_VTO req_VAO ADAP_gain_VPI ADAPDPI_gain_VNI ADAPDPI_cap_VTO ack_VAI
+ ADAPDPI_lk_VNI REF_lk_VNI vssa REF_cap_VTO PULEXT_pwbias_VPI DPI_in_UNI
*.PININFO REF_lk_VNI:I vssa:B vdda:B req_VAO:O ack_VAI:I DPI_lk_VNI:I ADAP_gain_VPI:I ADAPDPI_gain_VNI:I ADAPDPI_lk_VNI:I
*+ ADAPDPI_cap_VTO:O SOM_mem_VTO:O REF_cap_VTO:O PULEXT_pwbias_VPI:I DPI_gain_VNI:I DPI_in_UNI:B
Xfb vdda FB_cmpstate_VABO SOM_mem_VTO vssa FB_system
Xadap vdda PULEXT_ackext_VABO ADAPDPI_cap_VTO ADAP_gain_VPI DPI_in_UNI ADAPDPI_gain_VNI ADAPDPI_lk_VNI vssa ADAP_system
Xref net2 SOM_mem_VTO net1 REF_cap_VTO vssa REF_lk_VNI vdda REF_system
xext vdda vssa net3 ack_VAI PULEXT_pwbias_VPI PULEXT_cap_VP pulse_extender_V2
Xinv2 vdda net1 req_VAO vssa inv
Xinv3 vdda net2 ack_VAI vssa inv
Xinv4 vdda PULEXT_ackext_VABO net3 vssa inv
x1 vdda req_VAO FB_cmpstate_VABO vssa inv_hc
Xdpi1 DPI_in_UNI vdda SOM_mem_VTO DPI_gain_VNI vssa DPI_lk_VNI DPI_gain
x2 SOM_mem_VTO vssa cfringe60x8
x3 ADAPDPI_cap_VTO vssa cfringe35x8
x4 REF_cap_VTO vssa cfringe35x8
x5 PULEXT_cap_VP vssa cfringe6x3
.ends

* expanding   symbol:  V2I.sym # of pins=6
** sym_path: /foss/designs/ihp_INI_project/INI_Block/V2I.sym
** sch_path: /foss/designs/ihp_INI_project/INI_Block/V2I.sch
.subckt V2I vdda imax_VPI inputcm_VNI inputcm_VPI out_UPO vssa
*.PININFO inputcm_VNI:I inputcm_VPI:I out_UPO:O imax_VPI:I vdda:B vssa:B
MMIRA Vm Vm vssa vssa sg13_hv_nmos w=4u l=1u ng=2 m=4
MMBIAS Vb imax_VPI vdda vdda sg13_hv_pmos w=4u l=1u ng=2 m=4
MMIRB out_UPO Vm vssa vssa sg13_hv_nmos w=4u l=1u ng=2 m=4
MMdiffINN out_UPO inputcm_VNI Vb vdda sg13_hv_pmos w=4u l=1u ng=2 m=4
MMIDC out_UPO imax_VPI vdda vdda sg13_hv_pmos w=3u l=1u ng=2 m=4
MMdiffINP Vm inputcm_VPI Vb vdda sg13_hv_pmos w=4u l=1u ng=2 m=4
MMDdiffINP Vb Vb Vb vdda sg13_hv_pmos w=4u l=1u ng=2 m=2
MMDdiffINN Vb Vb Vb vdda sg13_hv_pmos w=4u l=1u ng=2 m=2
.ends

* expanding   symbol:  CoreFineDAC_N.sym # of pins=7
** sym_path: /foss/designs/ihp_INI_project/INI_Block/CoreFineDAC_N.sym
** sch_path: /foss/designs/ihp_INI_project/INI_Block/CoreFineDAC_N.sch
.subckt CoreFineDAC_N en_VS[10] en_VS[9] en_VS[8] en_VS[7] en_VS[6] en_VS[5] en_VS[4] en_VS[3] en_VS[2] en_VS[1] en_VS[0] vssa
+ vdda bias_VP bias_VN MASTER_CoreDiodeT_bias_VN[7] MASTER_CoreDiodeT_bias_VN[6] MASTER_CoreDiodeT_bias_VN[5]
+ MASTER_CoreDiodeT_bias_VN[4] MASTER_CoreDiodeT_bias_VN[3] MASTER_CoreDiodeT_bias_VN[2] MASTER_CoreDiodeT_bias_VN[1] MASTER_CoreDiodeT_bias_VN[0] BIASGEN_en_VS
*.PININFO MASTER_CoreDiodeT_bias_VN[7:0]:I en_VS[10:0]:I vssa:B vdda:B bias_VP:B bias_VN:B BIASGEN_en_VS:I
xinv[10] vdda en_VSB[10] en_VS[10] vssa inv_BG
xinv[9] vdda en_VSB[9] en_VS[9] vssa inv_BG
xinv[8] vdda en_VSB[8] en_VS[8] vssa inv_BG
xinv[7] vdda en_VSB[7] en_VS[7] vssa inv_BG
xinv[6] vdda en_VSB[6] en_VS[6] vssa inv_BG
xinv[5] vdda en_VSB[5] en_VS[5] vssa inv_BG
xinv[4] vdda en_VSB[4] en_VS[4] vssa inv_BG
xinv[3] vdda en_VSB[3] en_VS[3] vssa inv_BG
xinv[2] vdda en_VSB[2] en_VS[2] vssa inv_BG
xinv[1] vdda en_VSB[1] en_VS[1] vssa inv_BG
xinv[0] vdda en_VSB[0] en_VS[0] vssa inv_BG
x1 MASTER_CoreDiodeT_bias_VN[7] MASTER_CoreDiodeT_bias_VN[6] MASTER_CoreDiodeT_bias_VN[5] MASTER_CoreDiodeT_bias_VN[4]
+ MASTER_CoreDiodeT_bias_VN[3] MASTER_CoreDiodeT_bias_VN[2] MASTER_CoreDiodeT_bias_VN[1] MASTER_CoreDiodeT_bias_VN[0] vssa en_VS[10] en_VS[9] en_VS[8]
+ en_VSB[10] en_VSB[9] en_VSB[8] MASTER_biasout_VN SelMUX
xisink0[2] MASTER_biasout_VN vssa BIASGEN_en_VS net1 vssa ISINK
xisink0[1] MASTER_biasout_VN vssa BIASGEN_en_VS net1 vssa ISINK
MM1 net1 net1 vdda vdda sg13_hv_pmos w=2u l=1u ng=2 m=2
MM2 bias_test net1 vdda vdda sg13_hv_pmos w=2u l=1u ng=2 m=2
x4 en_VS[0] net7 net2 en_VSB[0] bias_test vssa vdda bias_VP SplitterCell
MM_enb vdda vdda net3 vssa sg13_hv_nmos w=1u l=1u ng=1
MM_s9 net2 bias_test net8 vssa sg13_hv_nmos w=2u l=10u ng=1
MM_s10 net8 bias_test net9 vssa sg13_hv_nmos w=2u l=10u ng=1
MM_s11 net9 bias_test net10 vssa sg13_hv_nmos w=2u l=10u ng=1
MM_s12 net10 bias_test net3 vssa sg13_hv_nmos w=2u l=10u ng=1
x5 en_VS[1] net11 net7 en_VSB[1] bias_test vssa vdda bias_VP SplitterCell
x6 en_VS[2] net12 net11 en_VSB[2] bias_test vssa vdda bias_VP SplitterCell
x7 en_VS[3] net13 net12 en_VSB[3] bias_test vssa vdda bias_VP SplitterCell
x8 en_VS[4] net14 net13 en_VSB[4] bias_test vssa vdda bias_VP SplitterCell
x9 en_VS[5] net15 net14 en_VSB[5] bias_test vssa vdda bias_VP SplitterCell
x10 en_VS[6] net16 net15 en_VSB[6] bias_test vssa vdda bias_VP SplitterCell
x11 en_VS[7] V_drain_ISINK net16 en_VSB[7] bias_test vssa vdda bias_VP SplitterCell
MM8 net4 bias_VP vdda vdda sg13_hv_pmos w=4u l=1u ng=1 m=2
MM7 net5 bias_VP vdda vdda sg13_hv_pmos w=4u l=1u ng=1 m=2
MM9 bias_VP MASTER_CoreDiodeT_bias_VN[2] net4 vdda sg13_hv_pmos w=4u l=0.5u ng=1 m=2
MM10 bias_VN MASTER_CoreDiodeT_bias_VN[2] net5 vdda sg13_hv_pmos w=4u l=0.5u ng=1 m=2
xisink2[2] bias_VN vssa BIASGEN_en_VS bias_VN vssa ISINK
xisink2[1] bias_VN vssa BIASGEN_en_VS bias_VN vssa ISINK
MM_b4 bias_test bias_test net6 vssa sg13_hv_nmos w=2u l=6u ng=1
xisink1[8] MASTER_biasout_VN vssa BIASGEN_en_VS V_drain_ISINK vssa ISINK
xisink1[7] MASTER_biasout_VN vssa BIASGEN_en_VS V_drain_ISINK vssa ISINK
xisink1[6] MASTER_biasout_VN vssa BIASGEN_en_VS V_drain_ISINK vssa ISINK
xisink1[5] MASTER_biasout_VN vssa BIASGEN_en_VS V_drain_ISINK vssa ISINK
xisink1[4] MASTER_biasout_VN vssa BIASGEN_en_VS V_drain_ISINK vssa ISINK
xisink1[3] MASTER_biasout_VN vssa BIASGEN_en_VS V_drain_ISINK vssa ISINK
xisink1[2] MASTER_biasout_VN vssa BIASGEN_en_VS V_drain_ISINK vssa ISINK
xisink1[1] MASTER_biasout_VN vssa BIASGEN_en_VS V_drain_ISINK vssa ISINK
MM_b3 net6 net6 vssa vssa sg13_hv_nmos w=2u l=6u ng=1
MM3 vdda vdda bias_VP vdda sg13_hv_pmos w=4u l=0.45u ng=1 m=2
MM4 vdda vdda bias_VN vdda sg13_hv_pmos w=4u l=0.45u ng=1 m=2
x2 bias_VN vssa cfringe33x55
x3 vdda bias_VP cfringe34x70
.ends

* expanding   symbol:  CoreDiodeT.sym # of pins=3
** sym_path: /foss/designs/ihp_INI_project/INI_Block/CoreDiodeT.sym
** sch_path: /foss/designs/ihp_INI_project/INI_Block/CoreDiodeT.sch
.subckt CoreDiodeT ref_VUN[7] ref_VUN[6] ref_VUN[5] ref_VUN[4] ref_VUN[3] ref_VUN[2] ref_VUN[1] ref_VUN[0] vssa en_VS
*.PININFO ref_VUN[7:0]:B en_VS:I vssa:B
x2[8] ref_VUN[7] vssa en_VS ref_VUN[7] vssa ISINK
x2[7] ref_VUN[7] vssa en_VS ref_VUN[7] vssa ISINK
x2[6] ref_VUN[7] vssa en_VS ref_VUN[7] vssa ISINK
x2[5] ref_VUN[7] vssa en_VS ref_VUN[7] vssa ISINK
x2[4] ref_VUN[7] vssa en_VS ref_VUN[7] vssa ISINK
x2[3] ref_VUN[7] vssa en_VS ref_VUN[7] vssa ISINK
x2[2] ref_VUN[7] vssa en_VS ref_VUN[7] vssa ISINK
x2[1] ref_VUN[7] vssa en_VS ref_VUN[7] vssa ISINK
x9[8] ref_VUN[6] vssa en_VS ref_VUN[6] vssa ISINK
x9[7] ref_VUN[6] vssa en_VS ref_VUN[6] vssa ISINK
x9[6] ref_VUN[6] vssa en_VS ref_VUN[6] vssa ISINK
x9[5] ref_VUN[6] vssa en_VS ref_VUN[6] vssa ISINK
x9[4] ref_VUN[6] vssa en_VS ref_VUN[6] vssa ISINK
x9[3] ref_VUN[6] vssa en_VS ref_VUN[6] vssa ISINK
x9[2] ref_VUN[6] vssa en_VS ref_VUN[6] vssa ISINK
x9[1] ref_VUN[6] vssa en_VS ref_VUN[6] vssa ISINK
x10[8] ref_VUN[5] vssa en_VS ref_VUN[5] vssa ISINK
x10[7] ref_VUN[5] vssa en_VS ref_VUN[5] vssa ISINK
x10[6] ref_VUN[5] vssa en_VS ref_VUN[5] vssa ISINK
x10[5] ref_VUN[5] vssa en_VS ref_VUN[5] vssa ISINK
x10[4] ref_VUN[5] vssa en_VS ref_VUN[5] vssa ISINK
x10[3] ref_VUN[5] vssa en_VS ref_VUN[5] vssa ISINK
x10[2] ref_VUN[5] vssa en_VS ref_VUN[5] vssa ISINK
x10[1] ref_VUN[5] vssa en_VS ref_VUN[5] vssa ISINK
x11[8] ref_VUN[4] vssa en_VS ref_VUN[4] vssa ISINK
x11[7] ref_VUN[4] vssa en_VS ref_VUN[4] vssa ISINK
x11[6] ref_VUN[4] vssa en_VS ref_VUN[4] vssa ISINK
x11[5] ref_VUN[4] vssa en_VS ref_VUN[4] vssa ISINK
x11[4] ref_VUN[4] vssa en_VS ref_VUN[4] vssa ISINK
x11[3] ref_VUN[4] vssa en_VS ref_VUN[4] vssa ISINK
x11[2] ref_VUN[4] vssa en_VS ref_VUN[4] vssa ISINK
x11[1] ref_VUN[4] vssa en_VS ref_VUN[4] vssa ISINK
x12[8] ref_VUN[3] vssa en_VS ref_VUN[3] vssa ISINK
x12[7] ref_VUN[3] vssa en_VS ref_VUN[3] vssa ISINK
x12[6] ref_VUN[3] vssa en_VS ref_VUN[3] vssa ISINK
x12[5] ref_VUN[3] vssa en_VS ref_VUN[3] vssa ISINK
x12[4] ref_VUN[3] vssa en_VS ref_VUN[3] vssa ISINK
x12[3] ref_VUN[3] vssa en_VS ref_VUN[3] vssa ISINK
x12[2] ref_VUN[3] vssa en_VS ref_VUN[3] vssa ISINK
x12[1] ref_VUN[3] vssa en_VS ref_VUN[3] vssa ISINK
x13[8] ref_VUN[2] vssa en_VS ref_VUN[2] vssa ISINK
x13[7] ref_VUN[2] vssa en_VS ref_VUN[2] vssa ISINK
x13[6] ref_VUN[2] vssa en_VS ref_VUN[2] vssa ISINK
x13[5] ref_VUN[2] vssa en_VS ref_VUN[2] vssa ISINK
x13[4] ref_VUN[2] vssa en_VS ref_VUN[2] vssa ISINK
x13[3] ref_VUN[2] vssa en_VS ref_VUN[2] vssa ISINK
x13[2] ref_VUN[2] vssa en_VS ref_VUN[2] vssa ISINK
x13[1] ref_VUN[2] vssa en_VS ref_VUN[2] vssa ISINK
x14[8] ref_VUN[1] vssa en_VS ref_VUN[1] vssa ISINK
x14[7] ref_VUN[1] vssa en_VS ref_VUN[1] vssa ISINK
x14[6] ref_VUN[1] vssa en_VS ref_VUN[1] vssa ISINK
x14[5] ref_VUN[1] vssa en_VS ref_VUN[1] vssa ISINK
x14[4] ref_VUN[1] vssa en_VS ref_VUN[1] vssa ISINK
x14[3] ref_VUN[1] vssa en_VS ref_VUN[1] vssa ISINK
x14[2] ref_VUN[1] vssa en_VS ref_VUN[1] vssa ISINK
x14[1] ref_VUN[1] vssa en_VS ref_VUN[1] vssa ISINK
x8[8] ref_VUN[0] vssa en_VS ref_VUN[0] vssa ISINK
x8[7] ref_VUN[0] vssa en_VS ref_VUN[0] vssa ISINK
x8[6] ref_VUN[0] vssa en_VS ref_VUN[0] vssa ISINK
x8[5] ref_VUN[0] vssa en_VS ref_VUN[0] vssa ISINK
x8[4] ref_VUN[0] vssa en_VS ref_VUN[0] vssa ISINK
x8[3] ref_VUN[0] vssa en_VS ref_VUN[0] vssa ISINK
x8[2] ref_VUN[0] vssa en_VS ref_VUN[0] vssa ISINK
x8[1] ref_VUN[0] vssa en_VS ref_VUN[0] vssa ISINK
x1 vssa ref_VUN[7] cfringe140x6
x2 vssa ref_VUN[6] cfringe140x6
x3 vssa ref_VUN[5] cfringe140x6
x4 vssa ref_VUN[4] cfringe140x6
x5 vssa ref_VUN[3] cfringe140x6
x6 vssa ref_VUN[2] cfringe140x6
x7 vssa ref_VUN[1] cfringe140x6
x8 vssa ref_VUN[0] cfringe140x6
.ends

* expanding   symbol:  FB_system.sym # of pins=4
** sym_path: /foss/designs/ihp_INI_project/INI_Block/FB_system.sym
** sch_path: /foss/designs/ihp_INI_project/INI_Block/FB_system.sch
.subckt FB_system vdda out V_mem vssa
*.PININFO out:O V_mem:B vssa:B vdda:B
MMmirr Vmir Vmir vdda vdda sg13_hv_pmos w=4u l=2u ng=4
MMmirl4 V_mem Vmir net1 vdda sg13_hv_pmos w=1u l=2u ng=1
MMthr out V_mem Vmir vdda sg13_hv_pmos w=4u l=2u ng=4
MMmem1 out V_mem net2 vssa sg13_hv_nmos w=1u l=2u ng=1 m=2
MMmirl3 net1 Vmir net3 vdda sg13_hv_pmos w=1u l=2u ng=1
MMmirl2 net3 Vmir net4 vdda sg13_hv_pmos w=1u l=2u ng=1
MMmirl1 net4 Vmir vdda vdda sg13_hv_pmos w=1u l=2u ng=1
MMmem2 net2 V_mem net5 vssa sg13_hv_nmos w=1u l=2u ng=1 m=2
MMmem3 net5 V_mem net6 vssa sg13_hv_nmos w=1u l=2u ng=1 m=2
MMmem4 net6 V_mem vssa vssa sg13_hv_nmos w=1u l=2u ng=1 m=2
MMdum6 out vdda vdda vdda sg13_hv_pmos w=1u l=2u ng=1 m=2
MMdum7 V_mem vdda vdda vdda sg13_hv_pmos w=1u l=2u ng=1
MMdum1 vssa vssa out vssa sg13_hv_nmos w=2u l=2u ng=2
MMdum2 vssa vssa vssa vssa sg13_hv_nmos w=12u l=2u ng=2
MMdum3 vdda vdda vdda vdda sg13_hv_pmos w=12u l=2u ng=2
.ends

* expanding   symbol:  ADAP_system.sym # of pins=8
** sym_path: /foss/designs/ihp_INI_project/INI_Block/ADAP_system.sym
** sch_path: /foss/designs/ihp_INI_project/INI_Block/ADAP_system.sch
.subckt ADAP_system vdda ackext_VABI DPI_capabias_VP gain_VPI in_UNO DPI_gain_VNI DPI_lk_VNI vssa
*.PININFO ackext_VABI:I gain_VPI:I DPI_gain_VNI:I DPI_lk_VNI:I vssa:B vdda:B DPI_capabias_VP:B in_UNO:B
MM21 net1 gain_VPI net_DM1_SM21 vdda sg13_hv_pmos w=4u l=4u ng=2 m=4
MM18 in_UNO DPI_capabias_VP vssa vssa sg13_hv_nmos w=4u l=4u ng=2 m=4
MM1 net_DM1_SM21 ackext_VABI vdda vdda sg13_hv_pmos w=1.2u l=4u ng=4
Xdpi2 net1 vdda DPI_capabias_VP DPI_gain_VNI vssa DPI_lk_VNI DPI_gain
MMdum5 net_DM1_SM21 vdda vdda vdda sg13_hv_pmos w=8.6u l=2.75u ng=1
.ends

* expanding   symbol:  REF_system.sym # of pins=7
** sym_path: /foss/designs/ihp_INI_project/INI_Block/REF_system.sym
** sch_path: /foss/designs/ihp_INI_project/INI_Block/REF_system.sch
.subckt REF_system ack_VABI mem_VNO req_VABI capabias_VPN vssa lk_VPI vdda
*.PININFO lk_VPI:I req_VABI:I ack_VABI:I capabias_VPN:B mem_VNO:O vssa:B vdda:B
MM10 capabias_VPN req_VABI net2 vdda sg13_hv_pmos w=1u l=0.5u ng=1
MM11 capabias_VPN req_VABI net1 vssa sg13_hv_nmos w=1u l=0.5u ng=1
MM12 net2 ack_VABI vdda vdda sg13_hv_pmos w=1u l=0.5u ng=1
MM13 mem_VNO capabias_VPN vssa vssa sg13_hv_nmos w=1u l=0.5u ng=1
MM14 net1 lk_VPI vssa vssa sg13_hv_nmos w=4u l=4u ng=2 m=4
.ends

* expanding   symbol:  pulse_extender_V2.sym # of pins=6
** sym_path: /foss/designs/ihp_INI_project/INI_Block/pulse_extender_V2.sym
** sch_path: /foss/designs/ihp_INI_project/INI_Block/pulse_extender_V2.sch
.subckt pulse_extender_V2 vdda vssa out_VAO in_VAI pwbias_VPI capa_VP
*.PININFO out_VAO:O pwbias_VPI:I in_VAI:I capa_VP:B vssa:B vdda:B
MMp1 out_VAO capa_VP vdda vdda sg13_hv_pmos w=4u l=2u ng=1
MMn1 out_VAO capa_VP vssa vssa sg13_hv_nmos w=4u l=2u ng=1
MMn4 capa_VP in_VAI vssa vssa sg13_hv_nmos w=4u l=2u ng=1
MMstarve4 capa_VP pwbias_VPI vdda vdda sg13_hv_pmos w=4u l=2u ng=1
MMp3 capa_VP out_VAO vdda vdda sg13_hv_pmos w=4u l=2u ng=1
MMdum2 vssa vssa vssa vssa sg13_hv_nmos w=12u l=2u ng=2
MMdum1 vdda vdda vdda vdda sg13_hv_pmos w=12u l=2u ng=2
.ends

* expanding   symbol:  inv.sym # of pins=4
** sym_path: /foss/designs/ihp_INI_project/INI_Block/inv.sym
** sch_path: /foss/designs/ihp_INI_project/INI_Block/inv.sch
.subckt inv vdda out in vssa
*.PININFO in:I out:O vssa:B vdda:B
MM1 out in vdda vdda sg13_hv_pmos w=4u l=0.5u ng=1
MM2 out in vssa vssa sg13_hv_nmos w=4u l=0.5u ng=1
.ends

* expanding   symbol:  inv_hc.sym # of pins=4
** sym_path: /foss/designs/ihp_INI_project/INI_Block/inv_hc.sym
** sch_path: /foss/designs/ihp_INI_project/INI_Block/inv_hc.sch
.subckt inv_hc vdda out in vssa
*.PININFO in:I out:O vssa:B vdda:B
MM1 out in vdda vdda sg13_hv_pmos w=10u l=0.5u ng=1
MM2 out in vssa vssa sg13_hv_nmos w=10u l=0.5u ng=1
.ends

* expanding   symbol:  DPI_gain.sym # of pins=6
** sym_path: /foss/designs/ihp_INI_project/INI_Block/DPI_gain.sym
** sch_path: /foss/designs/ihp_INI_project/INI_Block/DPI_gain.sch
.subckt DPI_gain in_UI vdda capabias_VPN gain_VNI vssa lk_VNI
*.PININFO gain_VNI:I lk_VNI:I capabias_VPN:B vssa:B vdda:B in_UI:B
MMdifl vssa gain_VNI in_UI vdda sg13_hv_pmos w=2u l=2u ng=2 m=8
MMdifr capabias_VPN capabias_VPN in_UI vdda sg13_hv_pmos w=2u l=2u ng=2 m=8
MMtau capabias_VPN lk_VNI vssa vssa sg13_hv_nmos w=4u l=4u ng=2 m=4
MMdum2 in_UI vdda vdda vdda sg13_hv_pmos w=1u l=2u ng=1 m=8
MM2 vdda vdda vdda vdda sg13_hv_pmos w=10u l=2u ng=1
.ends

* expanding   symbol:  cfringe60x8.sym # of pins=2
** sym_path: /foss/designs/ihp_INI_project/INI_Block/cfringe60x8.sym
** sch_path: /foss/designs/ihp_INI_project/INI_Block/cfringe60x8.sch
.subckt cfringe60x8 C2 C1
*.PININFO C1:B C2:B
CC1 C1 C2 cap_mfringe w=60.0u l=8.0u mmin=1 mmax=4
.ends

* expanding   symbol:  cfringe35x8.sym # of pins=2
** sym_path: /foss/designs/ihp_INI_project/INI_Block/cfringe35x8.sym
** sch_path: /foss/designs/ihp_INI_project/INI_Block/cfringe35x8.sch
.subckt cfringe35x8 C2 C1
*.PININFO C1:B C2:B
CC1 C1 C2 cap_mfringe w=35.0u l=8.0u mmin=1 mmax=4
.ends

* expanding   symbol:  cfringe6x3.sym # of pins=2
** sym_path: /foss/designs/ihp_INI_project/INI_Block/cfringe6x3.sym
** sch_path: /foss/designs/ihp_INI_project/INI_Block/cfringe6x3.sch
.subckt cfringe6x3 C2 C1
*.PININFO C1:B C2:B
CC1 C1 C2 cap_mfringe w=6.0u l=3.0u mmin=1 mmax=4
.ends

* expanding   symbol:  inv_BG.sym # of pins=4
** sym_path: /foss/designs/ihp_INI_project/INI_Block/inv_BG.sym
** sch_path: /foss/designs/ihp_INI_project/INI_Block/inv_BG.sch
.subckt inv_BG vdda out in vssa
*.PININFO in:I out:O vssa:B vdda:B
MM1 out in vdda vdda sg13_hv_pmos w=1u l=0.5u ng=1
MM2 out in vssa vssa sg13_hv_nmos w=1u l=0.5u ng=1
.ends

* expanding   symbol:  SelMUX.sym # of pins=5
** sym_path: /foss/designs/ihp_INI_project/INI_Block/SelMUX.sym
** sch_path: /foss/designs/ihp_INI_project/INI_Block/SelMUX.sch
.subckt SelMUX MASTER_bias_VN[7] MASTER_bias_VN[6] MASTER_bias_VN[5] MASTER_bias_VN[4] MASTER_bias_VN[3] MASTER_bias_VN[2]
+ MASTER_bias_VN[1] MASTER_bias_VN[0] vssa en_VS[10] en_VS[9] en_VS[8] en_VSB[10] en_VSB[9] en_VSB[8] MASTER_biasout_VN
*.PININFO MASTER_bias_VN[7:0]:I MASTER_biasout_VN:O en_VS[10:8]:I en_VSB[10:8]:I vssa:B
MMUX_L0_0 MASTER_bias_VN[7] en_VS[8] net1 vssa sg13_hv_nmos w=4.98u l=0.45u ng=6
MMUX_L0_1 MASTER_bias_VN[6] en_VSB[8] net1 vssa sg13_hv_nmos w=0.45u l=10u ng=1
MMUX_L0_2 MASTER_bias_VN[5] en_VS[8] net2 vssa sg13_hv_nmos w=0.45u l=10u ng=1
MMUX_L0_3 MASTER_bias_VN[4] en_VSB[8] net2 vssa sg13_hv_nmos w=0.45u l=10u ng=1
MMUX_L0_4 MASTER_bias_VN[3] en_VS[8] net3 vssa sg13_hv_nmos w=0.45u l=10u ng=1
MMUX_L0_5 MASTER_bias_VN[2] en_VSB[8] net3 vssa sg13_hv_nmos w=0.45u l=10u ng=1
MMUX_L0_6 MASTER_bias_VN[1] en_VS[8] net4 vssa sg13_hv_nmos w=0.45u l=10u ng=1
MMUX_L0_7 MASTER_bias_VN[0] en_VSB[8] net4 vssa sg13_hv_nmos w=0.45u l=10u ng=1
MMUX_L1_A net1 en_VS[9] net5 vssa sg13_hv_nmos w=4.98u l=0.45u ng=6
MMUX_L1_B net2 en_VSB[9] net5 vssa sg13_hv_nmos w=0.45u l=10u ng=1
MMUX_L1_C net3 en_VS[9] net6 vssa sg13_hv_nmos w=0.45u l=10u ng=1
MMUX_L1_D net4 en_VSB[9] net6 vssa sg13_hv_nmos w=0.45u l=10u ng=1
MMUX_L2_A net5 en_VS[10] MASTER_biasout_VN vssa sg13_hv_nmos w=5u l=0.45u ng=2
MMUX_L2_B net6 en_VSB[10] MASTER_biasout_VN vssa sg13_hv_nmos w=0.45u l=10u ng=1
.ends

* expanding   symbol:  ISINK.sym # of pins=5
** sym_path: /foss/designs/ihp_INI_project/INI_Block/ISINK.sym
** sch_path: /foss/designs/ihp_INI_project/INI_Block/ISINK.sch
.subckt ISINK bias_VN vssa en_VS io_UN bulk
*.PININFO en_VS:I vssa:B bias_VN:I io_UN:B bulk:B
MM1 io_UN en_VS net2 bulk sg13_hv_nmos w=2.5u l=0.5u ng=1
MM2 net2 bias_VN net1 bulk sg13_hv_nmos w=1u l=4u ng=1
MM3 net1 bias_VN vssa bulk sg13_hv_nmos w=1u l=4u ng=1
.ends

* expanding   symbol:  SplitterCell.sym # of pins=9
** sym_path: /foss/designs/ihp_INI_project/INI_Block/SplitterCell.sym
** sch_path: /foss/designs/ihp_INI_project/INI_Block/SplitterCell.sch
.subckt SplitterCell en_VS A_UN B_UN en_VSB bias_VN vssa out_UPB out_UP
*.PININFO en_VS:I en_VSB:I bias_VN:I B_UN:B out_UP:B out_UPB:B vssa:B A_UN:B
MM_en out_UP en_VS net1 vssa sg13_hv_nmos w=1u l=1u ng=1
MM_enb out_UPB en_VSB net1 vssa sg13_hv_nmos w=1u l=1u ng=1
MM_s1 net1 bias_VN net3 vssa sg13_hv_nmos w=2u l=10u ng=1
MM_s2 net3 bias_VN net4 vssa sg13_hv_nmos w=2u l=10u ng=1
MM_s3 net4 bias_VN net5 vssa sg13_hv_nmos w=2u l=10u ng=1
MM_s4 net5 bias_VN net2 vssa sg13_hv_nmos w=2u l=10u ng=1
MM_s5 net2 bias_VN net6 vssa sg13_hv_nmos w=2u l=10u ng=1
MM_s6 net6 bias_VN net7 vssa sg13_hv_nmos w=2u l=10u ng=1
MM_s7 net7 bias_VN net8 vssa sg13_hv_nmos w=2u l=10u ng=1
MM_s8 net8 bias_VN A_UN vssa sg13_hv_nmos w=2u l=10u ng=1
MM_s9 A_UN bias_VN net9 vssa sg13_hv_nmos w=2u l=10u ng=1
MM_s10 net9 bias_VN net10 vssa sg13_hv_nmos w=2u l=10u ng=1
MM_s11 net10 bias_VN net11 vssa sg13_hv_nmos w=2u l=10u ng=1
MM_s12 net11 bias_VN B_UN vssa sg13_hv_nmos w=2u l=10u ng=1
.ends

* expanding   symbol:  cfringe33x55.sym # of pins=2
** sym_path: /foss/designs/ihp_INI_project/INI_Block/cfringe33x55.sym
** sch_path: /foss/designs/ihp_INI_project/INI_Block/cfringe33x55.sch
.subckt cfringe33x55 C2 C1
*.PININFO C2:B C1:B
CC2 C2 C1 cap_mfringe w=4.44u l=5u mmin=1 mmax=4
CC5 C1 C2 cap_mfringe w=8.96u l=19.18u mmin=1 mmax=4
CC6 C1 C2 cap_mfringe w=19.73u l=31u mmin=1 mmax=4
.ends

* expanding   symbol:  cfringe34x70.sym # of pins=2
** sym_path: /foss/designs/ihp_INI_project/INI_Block/cfringe34x70.sym
** sch_path: /foss/designs/ihp_INI_project/INI_Block/cfringe34x70.sch
.subckt cfringe34x70 C2 C1
*.PININFO C1:B C2:B
CC3 C1 C2 cap_mfringe w=9.3750u l=22.5u mmin=1 mmax=4
CC1 C2 C1 cap_mfringe w=9.3750u l=11.26u mmin=1 mmax=4
CC4 C2 C1 cap_mfringe w=15u l=36.5u mmin=1 mmax=4
.ends

* expanding   symbol:  cfringe140x6.sym # of pins=2
** sym_path: /foss/designs/ihp_INI_project/INI_Block/cfringe140x6.sym
** sch_path: /foss/designs/ihp_INI_project/INI_Block/cfringe140x6.sch
.subckt cfringe140x6 C2 C1
*.PININFO C1:B C2:B
CC1 C1 C2 cap_mfringe w=140.0u l=6.37u mmin=1 mmax=4
.ends
