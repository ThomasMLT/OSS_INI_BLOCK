** sch_path: /foss/designs/ihp_INI_project/INI_Block/INI_Block.sch
**.subckt INI_Block NN1_REQ NN2_REQ NN3_REQ NN1_ACK NN2_ACK NN3_ACK BG_100mV BG_BIAS BG_100k BG_PROB NN2_MEM_PROB NN1_MEM_PROB
*+ NN3_MEM_PROB V2I_INN V2I_INP SPI_CS_N SPI_MISO SPI_SCK SPI_MOSI SPI_RST_N C2F_COMP C2F_REQ C2F_ACK VSS VDD
*.opin NN1_REQ
*.opin NN2_REQ
*.opin NN3_REQ
*.ipin NN1_ACK
*.ipin NN2_ACK
*.ipin NN3_ACK
*.iopin BG_100mV
*.ipin BG_BIAS
*.iopin BG_100k
*.iopin BG_PROB
*.opin NN2_MEM_PROB
*.opin NN1_MEM_PROB
*.opin NN3_MEM_PROB
*.ipin V2I_INN
*.ipin V2I_INP
*.ipin SPI_CS_N
*.opin SPI_MISO
*.ipin SPI_SCK
*.ipin SPI_MOSI
*.ipin SPI_RST_N
*.opin C2F_COMP
*.opin C2F_REQ
*.ipin C2F_ACK
*.iopin VSS
*.iopin VDD
x1 VDD NNDPI_gain_VNI NNDPI_lk_VNI NN1_MEM_PROB NN1_REQ NNADAP_gain_VPI NNADAPDPI_gain_VNI NN1_ADAP_cap_VTO NN1_ACK
+ NNADAPDPI_lk_VNI NNREF_lk_VNI VSS NN1_REF_cap_VTO NNPULEXT_pwbias_VPI net1 neuron
x2 BG_BIAS BIASGEN_BYP_en_VS[0] BG_100mV BIASGEN_EXT_REF_en_VS[0] VDD ref_VUN[7] ref_VUN[6] ref_VUN[6] ref_VUN[6] ref_VUN[6]
+ ref_VUN[6] ref_VUN[6] ref_VUN[6] ref_VUN[6] ref_VUN[6] ref_VUN[5] ref_VUN[5] ref_VUN[5] ref_VUN[5] ref_VUN[5] ref_VUN[5] ref_VUN[5]
+ ref_VUN[5] ref_VUN[5] ref_VUN[4] ref_VUN[4] ref_VUN[4] ref_VUN[4] ref_VUN[4] ref_VUN[4] ref_VUN[4] ref_VUN[4] ref_VUN[4] ref_VUN[3]
+ ref_VUN[3] ref_VUN[3] ref_VUN[3] ref_VUN[3] ref_VUN[3] ref_VUN[3] ref_VUN[3] ref_VUN[3] ref_VUN[2] ref_VUN[2] ref_VUN[2] ref_VUN[2]
+ ref_VUN[2] ref_VUN[2] ref_VUN[2] ref_VUN[2] ref_VUN[2] ref_VUN[1] ref_VUN[1] ref_VUN[1] ref_VUN[1] ref_VUN[1] ref_VUN[1] ref_VUN[1]
+ ref_VUN[1] ref_VUN[1] ref_VUN[0] ref_VUN[0] ref_VUN[0] ref_VUN[0] ref_VUN[0] ref_VUN[0] ref_VUN[0] ref_VUN[0] ref_VUN[0] BG_100k VSS
+ MasterBias
x5 ref_VUN[7] ref_VUN[6] ref_VUN[5] ref_VUN[4] ref_VUN[3] ref_VUN[2] ref_VUN[1] ref_VUN[0] VSS BIASGEN_en_VS[0] CoreDiodeT
x3 VDD V2I_imax_VPI V2I_INN V2I_INP net1 VSS V2I
x13 VDD NNDPI_gain_VNI NNDPI_lk_VNI NN2_MEM_PROB NN2_REQ NNADAP_gain_VPI NNADAPDPI_gain_VNI NN2_ADAP_cap_VTO NN2_ACK
+ NNADAPDPI_lk_VNI NNREF_lk_VNI VSS NN_2REF_cap_VTO NNPULEXT_pwbias_VPI net2 neuron
x14 VDD V2I_imax_VPI V2I_INN V2I_INP net2 VSS V2I
x15 VDD NNDPI_gain_VNI NNDPI_lk_VNI NN3_MEM_PROB NN3_REQ NNADAP_gain_VPI NNADAPDPI_gain_VNI NN3_ADAP_cap_VTO NN3_ACK
+ NNADAPDPI_lk_VNI NNREF_lk_VNI VSS NN3_REF_cap_VTO NNPULEXT_pwbias_VPI net3 neuron
x16 VDD V2I_imax_VPI V2I_INN V2I_INP net3 VSS V2I
x1 SPI_CS_N SPI_MISO mosi SPI_RST_N SPI_SCK VDD bias_gen_spi_top
x4 en_VS_8[10] en_VS_8[9] en_VS_8[8] en_VS_8[7] en_VS_8[6] en_VS_8[5] en_VS_8[4] en_VS_8[3] en_VS_8[2] en_VS_8[1] en_VS_8[0]
+ ref_VUN[7] ref_VUN[6] ref_VUN[5] ref_VUN[4] ref_VUN[3] ref_VUN[2] ref_VUN[1] ref_VUN[0] en_VS_9[10] en_VS_9[9] en_VS_9[8] en_VS_9[7]
+ en_VS_9[6] en_VS_9[5] en_VS_9[4] en_VS_9[3] en_VS_9[2] en_VS_9[1] en_VS_9[0] en_VS_0[10] en_VS_0[9] en_VS_0[8] en_VS_0[7] en_VS_0[6]
+ en_VS_0[5] en_VS_0[4] en_VS_0[3] en_VS_0[2] en_VS_0[1] en_VS_0[0] en_VS_1[10] en_VS_1[9] en_VS_1[8] en_VS_1[7] en_VS_1[6] en_VS_1[5]
+ en_VS_1[4] en_VS_1[3] en_VS_1[2] en_VS_1[1] en_VS_1[0] BIASGEN_en_VS[0] en_VS_10[10] en_VS_10[9] en_VS_10[8] en_VS_10[7] en_VS_10[6]
+ en_VS_10[5] en_VS_10[4] en_VS_10[3] en_VS_10[2] en_VS_10[1] en_VS_10[0] en_VS_3[10] en_VS_3[9] en_VS_3[8] en_VS_3[7] en_VS_3[6] en_VS_3[5]
+ en_VS_3[4] en_VS_3[3] en_VS_3[2] en_VS_3[1] en_VS_3[0] en_VS_7[10] en_VS_7[9] en_VS_7[8] en_VS_7[7] en_VS_7[6] en_VS_7[5] en_VS_7[4]
+ en_VS_7[3] en_VS_7[2] en_VS_7[1] en_VS_7[0] en_VS_4[10] en_VS_4[9] en_VS_4[8] en_VS_4[7] en_VS_4[6] en_VS_4[5] en_VS_4[4] en_VS_4[3]
+ en_VS_4[2] en_VS_4[1] en_VS_4[0] en_VS_6[10] en_VS_6[9] en_VS_6[8] en_VS_6[7] en_VS_6[6] en_VS_6[5] en_VS_6[4] en_VS_6[3] en_VS_6[2]
+ en_VS_6[1] en_VS_6[0] en_VS_2[10] en_VS_2[9] en_VS_2[8] en_VS_2[7] en_VS_2[6] en_VS_2[5] en_VS_2[4] en_VS_2[3] en_VS_2[2] en_VS_2[1]
+ en_VS_2[0] en_VS_5[10] en_VS_5[9] en_VS_5[8] en_VS_5[7] en_VS_5[6] en_VS_5[5] en_VS_5[4] en_VS_5[3] en_VS_5[2] en_VS_5[1] en_VS_5[0] C2F_Iin
+ NNPULEXT_pwbias_VPI NNDPI_gain_VNI NNREF_lk_VNI NNADAPDPI_lk_VNI NNADAPDPI_gain_VNI V2I_imax_VPI NNADAP_gain_VPI NNDPI_lk_VNI C2F_Vb BG_PROB VDD VSS
+ BiasBlock
* noconn #net5
* noconn BIASGEN_en_VS[10:1]
* noconn BIASGEN_BYP_en_VS[10:1]
* noconn BIASGEN_EXT_REF_en_VS[10:1]
* noconn C2F_en_VSBI[10:1]
**.ends

* expanding   symbol:  neuron.sym # of pins=15
** sym_path: /foss/designs/ihp_INI_project/INI_Block/neuron.sym
** sch_path: /foss/designs/ihp_INI_project/INI_Block/neuron.sch
.subckt neuron vdda DPI_gain_VNI DPI_lk_VNI SOM_mem_VTO req_VAO ADAP_gain_VPI ADAPDPI_gain_VNI ADAPDPI_cap_VTO ack_VAI
+ ADAPDPI_lk_VNI REF_lk_VNI vssa REF_cap_VTO PULEXT_pwbias_VPI DPI_in_UNI
*.ipin REF_lk_VNI
*.iopin vssa
*.iopin vdda
*.opin req_VAO
*.ipin ack_VAI
*.ipin DPI_lk_VNI
*.ipin ADAP_gain_VPI
*.ipin ADAPDPI_gain_VNI
*.ipin ADAPDPI_lk_VNI
*.opin ADAPDPI_cap_VTO
*.opin SOM_mem_VTO
*.opin REF_cap_VTO
*.ipin PULEXT_pwbias_VPI
*.ipin DPI_gain_VNI
*.iopin DPI_in_UNI
Xfb vdda FB_cmpstate_VABO SOM_mem_VTO vssa FB_system
Xadap vdda PULEXT_ackext_VABO ADAPDPI_cap_VTO ADAP_gain_VPI DPI_in_UNI ADAPDPI_gain_VNI ADAPDPI_lk_VNI vssa ADAP_system
Xref net2 SOM_mem_VTO net1 REF_cap_VTO vssa REF_lk_VNI vdda REF_system
xext vdda vssa net3 ack_VAI PULEXT_pwbias_VPI PULEXT_cap_VP pulse_extender_V2
Xinv2 vdda net1 req_VAO vssa inv
Xinv3 vdda net2 ack_VAI vssa inv
Xinv4 vdda PULEXT_ackext_VABO net3 vssa inv
XC6 SOM_mem_VTO vssa SOM_mem_VTO vssa sg13_hv_svaricap w=9.74u l=0.8u Nx=3
XC7 SOM_mem_VTO vssa SOM_mem_VTO vssa sg13_hv_svaricap w=9.74u l=0.8u Nx=3
XC4 PULEXT_cap_VP vssa PULEXT_cap_VP vssa sg13_hv_svaricap w=3.74u l=0.3u Nx=1
x1 vdda req_VAO FB_cmpstate_VABO vssa inv_hc
Xdpi1 DPI_in_UNI vdda SOM_mem_VTO DPI_gain_VNI vssa DPI_lk_VNI DPI_gain
XC1 SOM_mem_VTO vssa SOM_mem_VTO vssa sg13_hv_svaricap w=9.74u l=0.8u Nx=3
XC5 SOM_mem_VTO vssa SOM_mem_VTO vssa sg13_hv_svaricap w=9.74u l=0.8u Nx=3
XC8 SOM_mem_VTO vssa SOM_mem_VTO vssa sg13_hv_svaricap w=9.74u l=0.8u Nx=3
XC9 ADAPDPI_cap_VTO vssa ADAPDPI_cap_VTO vssa sg13_hv_svaricap w=9.74u l=0.8u Nx=3
XC10 ADAPDPI_cap_VTO vssa ADAPDPI_cap_VTO vssa sg13_hv_svaricap w=9.74u l=0.8u Nx=3
XC11 ADAPDPI_cap_VTO vssa ADAPDPI_cap_VTO vssa sg13_hv_svaricap w=9.74u l=0.8u Nx=3
XC2 REF_cap_VTO vssa REF_cap_VTO vssa sg13_hv_svaricap w=9.74u l=0.8u Nx=3
XC3 REF_cap_VTO vssa REF_cap_VTO vssa sg13_hv_svaricap w=9.74u l=0.8u Nx=3
XC12 REF_cap_VTO vssa REF_cap_VTO vssa sg13_hv_svaricap w=9.74u l=0.8u Nx=3
.ends

* expanding   symbol:  MasterBias.sym # of pins=15
** sym_path: /foss/designs/ihp_INI_project/INI_Block/MasterBias.sym
** sch_path: /foss/designs/ihp_INI_project/INI_Block/MasterBias.sch
.subckt MasterBias VBP_TIA BYP_EN VREF_100mV EXT_REF_EN VDDA IREF_1uA[0] IREF_100nA[8] IREF_100nA[7] IREF_100nA[6] IREF_100nA[5]
+ IREF_100nA[4] IREF_100nA[3] IREF_100nA[2] IREF_100nA[1] IREF_100nA[0] IREF_10nA[8] IREF_10nA[7] IREF_10nA[6] IREF_10nA[5] IREF_10nA[4]
+ IREF_10nA[3] IREF_10nA[2] IREF_10nA[1] IREF_10nA[0] IREF_1nA[8] IREF_1nA[7] IREF_1nA[6] IREF_1nA[5] IREF_1nA[4] IREF_1nA[3] IREF_1nA[2]
+ IREF_1nA[1] IREF_1nA[0] IREF_100pA[8] IREF_100pA[7] IREF_100pA[6] IREF_100pA[5] IREF_100pA[4] IREF_100pA[3] IREF_100pA[2] IREF_100pA[1]
+ IREF_100pA[0] IREF_10pA[8] IREF_10pA[7] IREF_10pA[6] IREF_10pA[5] IREF_10pA[4] IREF_10pA[3] IREF_10pA[2] IREF_10pA[1] IREF_10pA[0] IREF_1pA[8]
+ IREF_1pA[7] IREF_1pA[6] IREF_1pA[5] IREF_1pA[4] IREF_1pA[3] IREF_1pA[2] IREF_1pA[1] IREF_1pA[0] IREF_100fA[8] IREF_100fA[7] IREF_100fA[6]
+ IREF_100fA[5] IREF_100fA[4] IREF_100fA[3] IREF_100fA[2] IREF_100fA[1] IREF_100fA[0] VREG_pad VSSA
*.iopin
*+ IREF_100nA[8],IREF_100nA[7],IREF_100nA[6],IREF_100nA[5],IREF_100nA[4],IREF_100nA[3],IREF_100nA[2],IREF_100nA[1],IREF_100nA[0]
*.iopin IREF_10nA[8],IREF_10nA[7],IREF_10nA[6],IREF_10nA[5],IREF_10nA[4],IREF_10nA[3],IREF_10nA[2],IREF_10nA[1],IREF_10nA[0]
*.iopin IREF_1nA[8],IREF_1nA[7],IREF_1nA[6],IREF_1nA[5],IREF_1nA[4],IREF_1nA[3],IREF_1nA[2],IREF_1nA[1],IREF_1nA[0]
*.iopin
*+ IREF_100pA[8],IREF_100pA[7],IREF_100pA[6],IREF_100pA[5],IREF_100pA[4],IREF_100pA[3],IREF_100pA[2],IREF_100pA[1],IREF_100pA[0]
*.iopin IREF_10pA[8],IREF_10pA[7],IREF_10pA[6],IREF_10pA[5],IREF_10pA[4],IREF_10pA[3],IREF_10pA[2],IREF_10pA[1],IREF_10pA[0]
*.iopin IREF_1pA[8],IREF_1pA[7],IREF_1pA[6],IREF_1pA[5],IREF_1pA[4],IREF_1pA[3],IREF_1pA[2],IREF_1pA[1],IREF_1pA[0]
*.iopin
*+ IREF_100fA[8],IREF_100fA[7],IREF_100fA[6],IREF_100fA[5],IREF_100fA[4],IREF_100fA[3],IREF_100fA[2],IREF_100fA[1],IREF_100fA[0]
*.iopin VSSA
*.iopin IREF_1uA[0]
*.ipin VREF_100mV
*.ipin VBP_TIA
*.iopin VDDA
*.ipin BYP_EN
*.ipin EXT_REF_EN
*.iopin VREG_pad
XMnbias VREG_pad EXT_REF_EN net8 VSSA sg13_hv_nmos w=25u l=500n ng=20
x_ota VDDA VBP_TIA net8 VREF_100mV VBIAS VSSA OTA_b
XC1 VDDA VSSA cap_mfringe w=45.0u l=25.0u mmin=1 mmax=4
R1 VSSA net10 100k
XC2 VDDA VSSA cap_mfringe w=45.0u l=32.0u mmin=1 mmax=4
XMnbias1 net10 EXT_REF_ENB net8 VSSA sg13_hv_nmos w=25u l=500n ng=20
XMnbias2 net8 VBIAS net9 VSSA sg13_hv_nmos w=25u l=500n ng=20
XMnbias3 net8 BYP_EN net9 VSSA sg13_hv_nmos w=25u l=500n ng=20
x1 VDDA net9 IREF_100nA[8] net2 VSSA DecadeDivider_2
x2 VDDA net3 IREF_1nA[8] net4 VSSA DecadeDivider_2
x3 VDDA net2 IREF_10nA[8] net3 VSSA DecadeDivider_2
x4 VDDA net4 IREF_100pA[8] net5 VSSA DecadeDivider_2
x5 VDDA net5 IREF_10pA[8] net6 VSSA DecadeDivider_2
x6 VDDA net6 IREF_1pA[8] net7 VSSA DecadeDivider_2
x7 VDDA net7 IREF_100fA[8] net1 VSSA DecadeDivider_2
x8 VDDA net9 IREF_1uA[0] VSSA DecadeDividerAux
xinv VDDA EXT_REF_ENB EXT_REF_EN VSSA inv_BG
.ends

* expanding   symbol:  CoreDiodeT.sym # of pins=3
** sym_path: /foss/designs/ihp_INI_project/INI_Block/CoreDiodeT.sym
** sch_path: /foss/designs/ihp_INI_project/INI_Block/CoreDiodeT.sch
.subckt CoreDiodeT ref_VUN[7] ref_VUN[6] ref_VUN[5] ref_VUN[4] ref_VUN[3] ref_VUN[2] ref_VUN[1] ref_VUN[0] vssa en_VS
*.iopin ref_VUN[7],ref_VUN[6],ref_VUN[5],ref_VUN[4],ref_VUN[3],ref_VUN[2],ref_VUN[1],ref_VUN[0]
*.ipin en_VS
*.iopin vssa
x2[8] ref_VUN[7] vssa en_VS ref_VUN[7] ISINK
x2[7] ref_VUN[7] vssa en_VS ref_VUN[7] ISINK
x2[6] ref_VUN[7] vssa en_VS ref_VUN[7] ISINK
x2[5] ref_VUN[7] vssa en_VS ref_VUN[7] ISINK
x2[4] ref_VUN[7] vssa en_VS ref_VUN[7] ISINK
x2[3] ref_VUN[7] vssa en_VS ref_VUN[7] ISINK
x2[2] ref_VUN[7] vssa en_VS ref_VUN[7] ISINK
x2[1] ref_VUN[7] vssa en_VS ref_VUN[7] ISINK
x9[8] ref_VUN[6] vssa en_VS ref_VUN[6] ISINK
x9[7] ref_VUN[6] vssa en_VS ref_VUN[6] ISINK
x9[6] ref_VUN[6] vssa en_VS ref_VUN[6] ISINK
x9[5] ref_VUN[6] vssa en_VS ref_VUN[6] ISINK
x9[4] ref_VUN[6] vssa en_VS ref_VUN[6] ISINK
x9[3] ref_VUN[6] vssa en_VS ref_VUN[6] ISINK
x9[2] ref_VUN[6] vssa en_VS ref_VUN[6] ISINK
x9[1] ref_VUN[6] vssa en_VS ref_VUN[6] ISINK
x10[8] ref_VUN[5] vssa en_VS ref_VUN[5] ISINK
x10[7] ref_VUN[5] vssa en_VS ref_VUN[5] ISINK
x10[6] ref_VUN[5] vssa en_VS ref_VUN[5] ISINK
x10[5] ref_VUN[5] vssa en_VS ref_VUN[5] ISINK
x10[4] ref_VUN[5] vssa en_VS ref_VUN[5] ISINK
x10[3] ref_VUN[5] vssa en_VS ref_VUN[5] ISINK
x10[2] ref_VUN[5] vssa en_VS ref_VUN[5] ISINK
x10[1] ref_VUN[5] vssa en_VS ref_VUN[5] ISINK
x11[8] ref_VUN[4] vssa en_VS ref_VUN[4] ISINK
x11[7] ref_VUN[4] vssa en_VS ref_VUN[4] ISINK
x11[6] ref_VUN[4] vssa en_VS ref_VUN[4] ISINK
x11[5] ref_VUN[4] vssa en_VS ref_VUN[4] ISINK
x11[4] ref_VUN[4] vssa en_VS ref_VUN[4] ISINK
x11[3] ref_VUN[4] vssa en_VS ref_VUN[4] ISINK
x11[2] ref_VUN[4] vssa en_VS ref_VUN[4] ISINK
x11[1] ref_VUN[4] vssa en_VS ref_VUN[4] ISINK
x12[8] ref_VUN[3] vssa en_VS ref_VUN[3] ISINK
x12[7] ref_VUN[3] vssa en_VS ref_VUN[3] ISINK
x12[6] ref_VUN[3] vssa en_VS ref_VUN[3] ISINK
x12[5] ref_VUN[3] vssa en_VS ref_VUN[3] ISINK
x12[4] ref_VUN[3] vssa en_VS ref_VUN[3] ISINK
x12[3] ref_VUN[3] vssa en_VS ref_VUN[3] ISINK
x12[2] ref_VUN[3] vssa en_VS ref_VUN[3] ISINK
x12[1] ref_VUN[3] vssa en_VS ref_VUN[3] ISINK
x13[8] ref_VUN[2] vssa en_VS ref_VUN[2] ISINK
x13[7] ref_VUN[2] vssa en_VS ref_VUN[2] ISINK
x13[6] ref_VUN[2] vssa en_VS ref_VUN[2] ISINK
x13[5] ref_VUN[2] vssa en_VS ref_VUN[2] ISINK
x13[4] ref_VUN[2] vssa en_VS ref_VUN[2] ISINK
x13[3] ref_VUN[2] vssa en_VS ref_VUN[2] ISINK
x13[2] ref_VUN[2] vssa en_VS ref_VUN[2] ISINK
x13[1] ref_VUN[2] vssa en_VS ref_VUN[2] ISINK
x14[8] ref_VUN[1] vssa en_VS ref_VUN[1] ISINK
x14[7] ref_VUN[1] vssa en_VS ref_VUN[1] ISINK
x14[6] ref_VUN[1] vssa en_VS ref_VUN[1] ISINK
x14[5] ref_VUN[1] vssa en_VS ref_VUN[1] ISINK
x14[4] ref_VUN[1] vssa en_VS ref_VUN[1] ISINK
x14[3] ref_VUN[1] vssa en_VS ref_VUN[1] ISINK
x14[2] ref_VUN[1] vssa en_VS ref_VUN[1] ISINK
x14[1] ref_VUN[1] vssa en_VS ref_VUN[1] ISINK
x8[8] ref_VUN[0] vssa en_VS ref_VUN[0] ISINK
x8[7] ref_VUN[0] vssa en_VS ref_VUN[0] ISINK
x8[6] ref_VUN[0] vssa en_VS ref_VUN[0] ISINK
x8[5] ref_VUN[0] vssa en_VS ref_VUN[0] ISINK
x8[4] ref_VUN[0] vssa en_VS ref_VUN[0] ISINK
x8[3] ref_VUN[0] vssa en_VS ref_VUN[0] ISINK
x8[2] ref_VUN[0] vssa en_VS ref_VUN[0] ISINK
x8[1] ref_VUN[0] vssa en_VS ref_VUN[0] ISINK
C0 ref_VUN[0] vssa 2p
C1 ref_VUN[1] vssa 2p
C2 ref_VUN[2] vssa 2p
C3 ref_VUN[3] vssa 2p
C4 ref_VUN[4] vssa 2p
C5 ref_VUN[5] vssa 2p
C6 ref_VUN[6] vssa 2p
C7 ref_VUN[7] vssa 2p
.ends

* expanding   symbol:  V2I.sym # of pins=6
** sym_path: /foss/designs/ihp_INI_project/INI_Block/V2I.sym
** sch_path: /foss/designs/ihp_INI_project/INI_Block/V2I.sch
.subckt V2I vdda imax_VPI inputcm_VNI inputcm_VPI out_UPO vssa
*.ipin inputcm_VNI
*.ipin inputcm_VPI
*.opin out_UPO
*.ipin imax_VPI
*.iopin vdda
*.iopin vssa
XMIRA Vm Vm vssa vssa sg13_hv_nmos w=4u l=1u ng=2 m=4
XMBIAS Vb imax_VPI vdda vdda sg13_hv_pmos w=4u l=1u ng=2 m=4
XMIRB out_UPO Vm vssa vssa sg13_hv_nmos w=4u l=1u ng=2 m=4
XMdiffINN out_UPO inputcm_VNI Vb vdda sg13_hv_pmos w=4u l=1u ng=2 m=4
XMIDC out_UPO imax_VPI vdda vdda sg13_hv_pmos w=3u l=1u ng=2 m=4
XMdiffINP Vm inputcm_VPI Vb vdda sg13_hv_pmos w=4u l=1u ng=2 m=4
XMDdiffINP Vb Vb Vb vdda sg13_hv_pmos w=4u l=1u ng=2 m=2
XMDdiffINN Vb Vb Vb vdda sg13_hv_pmos w=4u l=1u ng=2 m=2
.ends

* expanding   symbol:  bias_gen_spi_top.sym # of pins=23
** sym_path: /foss/designs/ihp_INI_project/INI_Block/bias_gen_spi_top.sym
.include ./bias_gen_spi_top_lvs.spice

* expanding   symbol:  BiasBlock.sym # of pins=26
** sym_path: /foss/designs/ihp_INI_project/INI_Block/BiasBlock.sym
** sch_path: /foss/designs/ihp_INI_project/INI_Block/BiasBlock.sch
.subckt BiasBlock en_VS_8[10] en_VS_8[9] en_VS_8[8] en_VS_8[7] en_VS_8[6] en_VS_8[5] en_VS_8[4] en_VS_8[3] en_VS_8[2] en_VS_8[1]
+ en_VS_8[0] ref_VUN[7] ref_VUN[6] ref_VUN[5] ref_VUN[4] ref_VUN[3] ref_VUN[2] ref_VUN[1] ref_VUN[0] en_VS_9[10] en_VS_9[9] en_VS_9[8]
+ en_VS_9[7] en_VS_9[6] en_VS_9[5] en_VS_9[4] en_VS_9[3] en_VS_9[2] en_VS_9[1] en_VS_9[0] en_VS_0[10] en_VS_0[9] en_VS_0[8] en_VS_0[7]
+ en_VS_0[6] en_VS_0[5] en_VS_0[4] en_VS_0[3] en_VS_0[2] en_VS_0[1] en_VS_0[0] en_VS_1[10] en_VS_1[9] en_VS_1[8] en_VS_1[7] en_VS_1[6]
+ en_VS_1[5] en_VS_1[4] en_VS_1[3] en_VS_1[2] en_VS_1[1] en_VS_1[0] BIASGEN_en_VS en_VS_10[10] en_VS_10[9] en_VS_10[8] en_VS_10[7] en_VS_10[6]
+ en_VS_10[5] en_VS_10[4] en_VS_10[3] en_VS_10[2] en_VS_10[1] en_VS_10[0] en_VS_3[10] en_VS_3[9] en_VS_3[8] en_VS_3[7] en_VS_3[6] en_VS_3[5]
+ en_VS_3[4] en_VS_3[3] en_VS_3[2] en_VS_3[1] en_VS_3[0] en_VS_7[10] en_VS_7[9] en_VS_7[8] en_VS_7[7] en_VS_7[6] en_VS_7[5] en_VS_7[4]
+ en_VS_7[3] en_VS_7[2] en_VS_7[1] en_VS_7[0] en_VS_4[10] en_VS_4[9] en_VS_4[8] en_VS_4[7] en_VS_4[6] en_VS_4[5] en_VS_4[4] en_VS_4[3]
+ en_VS_4[2] en_VS_4[1] en_VS_4[0] en_VS_6[10] en_VS_6[9] en_VS_6[8] en_VS_6[7] en_VS_6[6] en_VS_6[5] en_VS_6[4] en_VS_6[3] en_VS_6[2]
+ en_VS_6[1] en_VS_6[0] en_VS_2[10] en_VS_2[9] en_VS_2[8] en_VS_2[7] en_VS_2[6] en_VS_2[5] en_VS_2[4] en_VS_2[3] en_VS_2[2] en_VS_2[1]
+ en_VS_2[0] en_VS_5[10] en_VS_5[9] en_VS_5[8] en_VS_5[7] en_VS_5[6] en_VS_5[5] en_VS_5[4] en_VS_5[3] en_VS_5[2] en_VS_5[1] en_VS_5[0] C2F_Iin
+ NNPULEXT_pwbias_VPI NNDPI_gain_VNI NNREF_lk_VNI NNADAPDPI_lk_VNI NNADAPDPI_gain_VNI V2I_imax_VPI NNADAP_gain_VPI NNDPI_lk_VNI C2F_Vb BG_PROB VDD VSS
*.ipin en_VS_1[10],en_VS_1[9],en_VS_1[8],en_VS_1[7],en_VS_1[6],en_VS_1[5],en_VS_1[4],en_VS_1[3],en_VS_1[2],en_VS_1[1],en_VS_1[0]
*.opin NNDPI_gain_VNI
*.ipin en_VS_2[10],en_VS_2[9],en_VS_2[8],en_VS_2[7],en_VS_2[6],en_VS_2[5],en_VS_2[4],en_VS_2[3],en_VS_2[2],en_VS_2[1],en_VS_2[0]
*.opin NNDPI_lk_VNI
*.ipin en_VS_3[10],en_VS_3[9],en_VS_3[8],en_VS_3[7],en_VS_3[6],en_VS_3[5],en_VS_3[4],en_VS_3[3],en_VS_3[2],en_VS_3[1],en_VS_3[0]
*.ipin en_VS_4[10],en_VS_4[9],en_VS_4[8],en_VS_4[7],en_VS_4[6],en_VS_4[5],en_VS_4[4],en_VS_4[3],en_VS_4[2],en_VS_4[1],en_VS_4[0]
*.opin NNPULEXT_pwbias_VPI
*.opin NNADAP_gain_VPI
*.ipin en_VS_5[10],en_VS_5[9],en_VS_5[8],en_VS_5[7],en_VS_5[6],en_VS_5[5],en_VS_5[4],en_VS_5[3],en_VS_5[2],en_VS_5[1],en_VS_5[0]
*.ipin en_VS_6[10],en_VS_6[9],en_VS_6[8],en_VS_6[7],en_VS_6[6],en_VS_6[5],en_VS_6[4],en_VS_6[3],en_VS_6[2],en_VS_6[1],en_VS_6[0]
*.ipin en_VS_7[10],en_VS_7[9],en_VS_7[8],en_VS_7[7],en_VS_7[6],en_VS_7[5],en_VS_7[4],en_VS_7[3],en_VS_7[2],en_VS_7[1],en_VS_7[0]
*.ipin en_VS_0[10],en_VS_0[9],en_VS_0[8],en_VS_0[7],en_VS_0[6],en_VS_0[5],en_VS_0[4],en_VS_0[3],en_VS_0[2],en_VS_0[1],en_VS_0[0]
*.ipin BIASGEN_en_VS
*.iopin VSS
*.iopin VDD
*.ipin ref_VUN[7],ref_VUN[6],ref_VUN[5],ref_VUN[4],ref_VUN[3],ref_VUN[2],ref_VUN[1],ref_VUN[0]
*.opin V2I_imax_VPI
*.opin NNADAPDPI_gain_VNI
*.opin NNADAPDPI_lk_VNI
*.opin NNREF_lk_VNI
*.ipin en_VS_8[10],en_VS_8[9],en_VS_8[8],en_VS_8[7],en_VS_8[6],en_VS_8[5],en_VS_8[4],en_VS_8[3],en_VS_8[2],en_VS_8[1],en_VS_8[0]
*.ipin en_VS_9[10],en_VS_9[9],en_VS_9[8],en_VS_9[7],en_VS_9[6],en_VS_9[5],en_VS_9[4],en_VS_9[3],en_VS_9[2],en_VS_9[1],en_VS_9[0]
*.ipin
*+ en_VS_10[10],en_VS_10[9],en_VS_10[8],en_VS_10[7],en_VS_10[6],en_VS_10[5],en_VS_10[4],en_VS_10[3],en_VS_10[2],en_VS_10[1],en_VS_10[0]
*.opin BG_PROB
*.opin C2F_Iin
*.opin C2F_Vb
x6 en_VS_1[10] en_VS_1[9] en_VS_1[8] en_VS_1[7] en_VS_1[6] en_VS_1[5] en_VS_1[4] en_VS_1[3] en_VS_1[2] en_VS_1[1] en_VS_1[0] VSS
+ VDD net1 NNDPI_gain_VNI ref_VUN[7] ref_VUN[6] ref_VUN[5] ref_VUN[4] ref_VUN[3] ref_VUN[2] ref_VUN[1] ref_VUN[0] BIASGEN_en_VS
+ CoreFineDAC_N
x4 en_VS_2[10] en_VS_2[9] en_VS_2[8] en_VS_2[7] en_VS_2[6] en_VS_2[5] en_VS_2[4] en_VS_2[3] en_VS_2[2] en_VS_2[1] en_VS_2[0] VSS
+ VDD net2 NNDPI_lk_VNI ref_VUN[7] ref_VUN[6] ref_VUN[5] ref_VUN[4] ref_VUN[3] ref_VUN[2] ref_VUN[1] ref_VUN[0] BIASGEN_en_VS
+ CoreFineDAC_N
x7 en_VS_3[10] en_VS_3[9] en_VS_3[8] en_VS_3[7] en_VS_3[6] en_VS_3[5] en_VS_3[4] en_VS_3[3] en_VS_3[2] en_VS_3[1] en_VS_3[0] VSS
+ VDD NNPULEXT_pwbias_VPI net3 ref_VUN[7] ref_VUN[6] ref_VUN[5] ref_VUN[4] ref_VUN[3] ref_VUN[2] ref_VUN[1] ref_VUN[0] BIASGEN_en_VS
+ CoreFineDAC_N
x8 en_VS_4[10] en_VS_4[9] en_VS_4[8] en_VS_4[7] en_VS_4[6] en_VS_4[5] en_VS_4[4] en_VS_4[3] en_VS_4[2] en_VS_4[1] en_VS_4[0] VSS
+ VDD NNADAP_gain_VPI net4 ref_VUN[7] ref_VUN[6] ref_VUN[5] ref_VUN[4] ref_VUN[3] ref_VUN[2] ref_VUN[1] ref_VUN[0] BIASGEN_en_VS
+ CoreFineDAC_N
x9 en_VS_5[10] en_VS_5[9] en_VS_5[8] en_VS_5[7] en_VS_5[6] en_VS_5[5] en_VS_5[4] en_VS_5[3] en_VS_5[2] en_VS_5[1] en_VS_5[0] VSS
+ VDD net5 NNADAPDPI_gain_VNI ref_VUN[7] ref_VUN[6] ref_VUN[5] ref_VUN[4] ref_VUN[3] ref_VUN[2] ref_VUN[1] ref_VUN[0] BIASGEN_en_VS
+ CoreFineDAC_N
x10 en_VS_6[10] en_VS_6[9] en_VS_6[8] en_VS_6[7] en_VS_6[6] en_VS_6[5] en_VS_6[4] en_VS_6[3] en_VS_6[2] en_VS_6[1] en_VS_6[0] VSS
+ VDD net6 NNADAPDPI_lk_VNI ref_VUN[7] ref_VUN[6] ref_VUN[5] ref_VUN[4] ref_VUN[3] ref_VUN[2] ref_VUN[1] ref_VUN[0] BIASGEN_en_VS
+ CoreFineDAC_N
x11 en_VS_7[10] en_VS_7[9] en_VS_7[8] en_VS_7[7] en_VS_7[6] en_VS_7[5] en_VS_7[4] en_VS_7[3] en_VS_7[2] en_VS_7[1] en_VS_7[0] VSS
+ VDD net7 NNREF_lk_VNI ref_VUN[7] ref_VUN[6] ref_VUN[5] ref_VUN[4] ref_VUN[3] ref_VUN[2] ref_VUN[1] ref_VUN[0] BIASGEN_en_VS
+ CoreFineDAC_N
x12 en_VS_0[10] en_VS_0[9] en_VS_0[8] en_VS_0[7] en_VS_0[6] en_VS_0[5] en_VS_0[4] en_VS_0[3] en_VS_0[2] en_VS_0[1] en_VS_0[0] VSS
+ VDD V2I_imax_VPI net8 ref_VUN[7] ref_VUN[6] ref_VUN[5] ref_VUN[4] ref_VUN[3] ref_VUN[2] ref_VUN[1] ref_VUN[0] BIASGEN_en_VS
+ CoreFineDAC_N
x17 en_VS_8[10] en_VS_8[9] en_VS_8[8] en_VS_8[7] en_VS_8[6] en_VS_8[5] en_VS_8[4] en_VS_8[3] en_VS_8[2] en_VS_8[1] en_VS_8[0] VSS
+ VDD C2F_Vb net9 ref_VUN[7] ref_VUN[6] ref_VUN[5] ref_VUN[4] ref_VUN[3] ref_VUN[2] ref_VUN[1] ref_VUN[0] BIASGEN_en_VS CoreFineDAC_N
x18 en_VS_9[10] en_VS_9[9] en_VS_9[8] en_VS_9[7] en_VS_9[6] en_VS_9[5] en_VS_9[4] en_VS_9[3] en_VS_9[2] en_VS_9[1] en_VS_9[0] VSS
+ VDD C2F_Iin net10 ref_VUN[7] ref_VUN[6] ref_VUN[5] ref_VUN[4] ref_VUN[3] ref_VUN[2] ref_VUN[1] ref_VUN[0] BIASGEN_en_VS CoreFineDAC_N
x19 en_VS_10[10] en_VS_10[9] en_VS_10[8] en_VS_10[7] en_VS_10[6] en_VS_10[5] en_VS_10[4] en_VS_10[3] en_VS_10[2] en_VS_10[1]
+ en_VS_10[0] VSS VDD BG_PROB net11 ref_VUN[7] ref_VUN[6] ref_VUN[5] ref_VUN[4] ref_VUN[3] ref_VUN[2] ref_VUN[1] ref_VUN[0] BIASGEN_en_VS
+ CoreFineDAC_N
* noconn #net8
* noconn #net1
* noconn #net2
* noconn #net3
* noconn #net4
* noconn #net5
* noconn #net6
* noconn #net7
* noconn #net9
* noconn #net10
* noconn #net11
.ends

* expanding   symbol:  FB_system.sym # of pins=4
** sym_path: /foss/designs/ihp_INI_project/INI_Block/FB_system.sym
** sch_path: /foss/designs/ihp_INI_project/INI_Block/FB_system.sch
.subckt FB_system vdda out V_mem vssa
*.opin out
*.iopin V_mem
*.iopin vssa
*.iopin vdda
XMmirr Vmir Vmir vdda vdda sg13_hv_pmos w=4u l=2u ng=4
XMmirl4 V_mem Vmir net1 vdda sg13_hv_pmos w=1u l=2u ng=1
XMthr out V_mem Vmir vdda sg13_hv_pmos w=4u l=2u ng=4
XMmem1 out V_mem net2 vssa sg13_hv_nmos w=1u l=2u ng=1 m=2
XMmirl3 net1 Vmir net3 vdda sg13_hv_pmos w=1u l=2u ng=1
XMmirl2 net3 Vmir net4 vdda sg13_hv_pmos w=1u l=2u ng=1
XMmirl1 net4 Vmir vdda vdda sg13_hv_pmos w=1u l=2u ng=1
XMmem2 net2 V_mem net5 vssa sg13_hv_nmos w=1u l=2u ng=1 m=2
XMmem3 net5 V_mem net6 vssa sg13_hv_nmos w=1u l=2u ng=1 m=2
XMmem4 net6 V_mem vssa vssa sg13_hv_nmos w=1u l=2u ng=1 m=2
XMdum6 out vdda vdda vdda sg13_hv_pmos w=1u l=2u ng=1 m=2
XMdum7 V_mem vdda vdda vdda sg13_hv_pmos w=1u l=2u ng=1
XMdum1 vssa vssa out vssa sg13_hv_nmos w=2u l=2u ng=2
.ends

* expanding   symbol:  ADAP_system.sym # of pins=8
** sym_path: /foss/designs/ihp_INI_project/INI_Block/ADAP_system.sym
** sch_path: /foss/designs/ihp_INI_project/INI_Block/ADAP_system.sch
.subckt ADAP_system vdda ackext_VABI DPI_capabias_VP gain_VPI in_UNO DPI_gain_VNI DPI_lk_VNI vssa
*.ipin ackext_VABI
*.ipin gain_VPI
*.ipin DPI_gain_VNI
*.ipin DPI_lk_VNI
*.iopin vssa
*.iopin vdda
*.iopin DPI_capabias_VP
*.iopin in_UNO
XM21 net1 gain_VPI net_DM1_SM21 vdda sg13_hv_pmos w=4u l=4u ng=2 m=4
XM18 in_UNO DPI_capabias_VP vssa vssa sg13_hv_nmos w=4u l=4u ng=2 m=4
XM1 net_DM1_SM21 ackext_VABI vdda vdda sg13_hv_pmos w=1.2u l=4u ng=4
Xdpi2 net1 vdda DPI_capabias_VP DPI_gain_VNI vssa DPI_lk_VNI DPI_gain
XMdum5 net_DM1_SM21 vdda vdda vdda sg13_hv_pmos w=8.6u l=2.75u ng=1
.ends

* expanding   symbol:  REF_system.sym # of pins=7
** sym_path: /foss/designs/ihp_INI_project/INI_Block/REF_system.sym
** sch_path: /foss/designs/ihp_INI_project/INI_Block/REF_system.sch
.subckt REF_system ack_VABI mem_VNO req_VABI capabias_VPN vssa lk_VPI vdda
*.ipin lk_VPI
*.ipin req_VABI
*.ipin ack_VABI
*.iopin capabias_VPN
*.opin mem_VNO
*.iopin vssa
*.iopin vdda
XM10 capabias_VPN req_VABI net2 vdda sg13_hv_pmos w=1u l=0.5u ng=1
XM11 capabias_VPN req_VABI net1 vssa sg13_hv_nmos w=1u l=0.5u ng=1
XM12 net2 ack_VABI vdda vdda sg13_hv_pmos w=1u l=0.5u ng=1
XM13 mem_VNO capabias_VPN vssa vssa sg13_hv_nmos w=1u l=0.5u ng=1
XM14 net1 lk_VPI vssa vssa sg13_hv_nmos w=4u l=4u ng=2 m=4
.ends

* expanding   symbol:  pulse_extender_V2.sym # of pins=6
** sym_path: /foss/designs/ihp_INI_project/INI_Block/pulse_extender_V2.sym
** sch_path: /foss/designs/ihp_INI_project/INI_Block/pulse_extender_V2.sch
.subckt pulse_extender_V2 vdda vssa out_VAO in_VAI pwbias_VPI capa_VP
*.opin out_VAO
*.ipin pwbias_VPI
*.ipin in_VAI
*.iopin capa_VP
*.iopin vssa
*.iopin vdda
XMp1 out_VAO capa_VP vdda vdda sg13_hv_pmos w=4u l=2u ng=1
XMn1 out_VAO capa_VP vssa vssa sg13_hv_nmos w=4u l=2u ng=1
XMn4 capa_VP in_VAI vssa vssa sg13_hv_nmos w=4u l=2u ng=1
XMstarve4 capa_VP pwbias_VPI vdda vdda sg13_hv_pmos w=4u l=2u ng=1
XMp3 capa_VP out_VAO vdda vdda sg13_hv_pmos w=4u l=2u ng=1
.ends

* expanding   symbol:  inv.sym # of pins=4
** sym_path: /foss/designs/ihp_INI_project/INI_Block/inv.sym
** sch_path: /foss/designs/ihp_INI_project/INI_Block/inv.sch
.subckt inv vdda out in vssa
*.ipin in
*.opin out
*.iopin vssa
*.iopin vdda
XM1 out in vdda vdda sg13_hv_pmos w=4u l=0.5u ng=1
XM2 out in vssa vssa sg13_hv_nmos w=4u l=0.5u ng=1
.ends

* expanding   symbol:  inv_hc.sym # of pins=4
** sym_path: /foss/designs/ihp_INI_project/INI_Block/inv_hc.sym
** sch_path: /foss/designs/ihp_INI_project/INI_Block/inv_hc.sch
.subckt inv_hc vdda out in vssa
*.ipin in
*.opin out
*.iopin vssa
*.iopin vdda
XM1 out in vdda vdda sg13_hv_pmos w=10u l=0.5u ng=1
XM2 out in vssa vssa sg13_hv_nmos w=10u l=0.5u ng=1
.ends

* expanding   symbol:  DPI_gain.sym # of pins=6
** sym_path: /foss/designs/ihp_INI_project/INI_Block/DPI_gain.sym
** sch_path: /foss/designs/ihp_INI_project/INI_Block/DPI_gain.sch
.subckt DPI_gain in_UI vdda capabias_VPN gain_VNI vssa lk_VNI
*.ipin gain_VNI
*.ipin lk_VNI
*.iopin capabias_VPN
*.iopin vssa
*.iopin vdda
*.iopin in_UI
XMdifl vssa gain_VNI in_UI vdda sg13_hv_pmos w=2u l=2u ng=2 m=8
XMdifr capabias_VPN capabias_VPN in_UI vdda sg13_hv_pmos w=2u l=2u ng=2 m=8
XMtau capabias_VPN lk_VNI vssa vssa sg13_hv_nmos w=4u l=4u ng=2 m=4
XMdum2 in_UI vdda vdda vdda sg13_hv_pmos w=1u l=2u ng=1 m=8
.ends

* expanding   symbol:  OTA_b.sym # of pins=6
** sym_path: /foss/designs/ihp_INI_project/INI_Block/OTA_b.sym
** sch_path: /foss/designs/ihp_INI_project/INI_Block/OTA_b.sch
.subckt OTA_b VDDA VBP INN INP VOP VSSA
*.ipin VBP
*.ipin INP
*.ipin INN
*.iopin VSSA
*.iopin VDDA
*.opin VOP
XM13 n1 n1 VSSA VSSA sg13_hv_nmos w=2u l=0.5u ng=2 m=2
XM1 n2 n2 VSSA VSSA sg13_hv_nmos w=2u l=0.5u ng=2 m=2
XM12 n1 INN vtail VDDA sg13_hv_pmos w=16u l=0.5u ng=2 m=4
XM3 n2 INP vtail VDDA sg13_hv_pmos w=16u l=0.5u ng=2 m=4
XM4 vtail VBP VDDA VDDA sg13_hv_pmos w=12u l=500n ng=2 m=8
XM5 vpmirr vpmirr VDDA VDDA sg13_hv_pmos w=2u l=500n ng=2 m=4
XM6 vout1stage vpmirr VDDA VDDA sg13_hv_pmos w=2u l=500n ng=2 m=4
XM7 vout1stage n1 VSSA VSSA sg13_hv_nmos w=1.75u l=0.5u ng=2 m=4
XM8 VOP vout1stage VSSA VSSA sg13_hv_nmos w=4u l=0.5u ng=4 m=4
XM9 VOP VBP VDDA VDDA sg13_hv_pmos w=4u l=0.5u ng=2
XM10 vpmirr n2 VSSA VSSA sg13_hv_nmos w=2u l=0.5u ng=2 m=4
R1 net1 vout1stage 49.84k
XC1 VOP net1 cap_mfringe w=28.0u l=10.0u mmin=1 mmax=4
.ends

* expanding   symbol:  DecadeDivider_2.sym # of pins=5
** sym_path: /foss/designs/ihp_INI_project/INI_Block/DecadeDivider_2.sym
** sch_path: /foss/designs/ihp_INI_project/INI_Block/DecadeDivider_2.sch
.subckt DecadeDivider_2 VDDA IREF IREF_CORE[0] IOUT VSSA
*.iopin VSSA
*.iopin VDDA
*.iopin IREF
*.iopin IREF_CORE[0]
*.iopin IOUT
x1[2] VDDA IREF IREF VSSA IREF_CORE[0] ISOURCE
x1[1] VDDA IREF IREF VSSA IREF_CORE[0] ISOURCE
x10[2] VDDA IREF IREF VSSA Vbn ISOURCE
x10[1] VDDA IREF IREF VSSA Vbn ISOURCE
x11[20] VDDA IREF IREF VSSA IREF ISOURCE
x11[19] VDDA IREF IREF VSSA IREF ISOURCE
x11[18] VDDA IREF IREF VSSA IREF ISOURCE
x11[17] VDDA IREF IREF VSSA IREF ISOURCE
x11[16] VDDA IREF IREF VSSA IREF ISOURCE
x11[15] VDDA IREF IREF VSSA IREF ISOURCE
x11[14] VDDA IREF IREF VSSA IREF ISOURCE
x11[13] VDDA IREF IREF VSSA IREF ISOURCE
x11[12] VDDA IREF IREF VSSA IREF ISOURCE
x11[11] VDDA IREF IREF VSSA IREF ISOURCE
x11[10] VDDA IREF IREF VSSA IREF ISOURCE
x11[9] VDDA IREF IREF VSSA IREF ISOURCE
x11[8] VDDA IREF IREF VSSA IREF ISOURCE
x11[7] VDDA IREF IREF VSSA IREF ISOURCE
x11[6] VDDA IREF IREF VSSA IREF ISOURCE
x11[5] VDDA IREF IREF VSSA IREF ISOURCE
x11[4] VDDA IREF IREF VSSA IREF ISOURCE
x11[3] VDDA IREF IREF VSSA IREF ISOURCE
x11[2] VDDA IREF IREF VSSA IREF ISOURCE
x11[1] VDDA IREF IREF VSSA IREF ISOURCE
x12[15] Vbn VSSA Vbn Vbn ISINK
x12[14] Vbn VSSA Vbn Vbn ISINK
x12[13] Vbn VSSA Vbn Vbn ISINK
x12[12] Vbn VSSA Vbn Vbn ISINK
x12[11] Vbn VSSA Vbn Vbn ISINK
x12[10] Vbn VSSA Vbn Vbn ISINK
x12[9] Vbn VSSA Vbn Vbn ISINK
x12[8] Vbn VSSA Vbn Vbn ISINK
x12[7] Vbn VSSA Vbn Vbn ISINK
x12[6] Vbn VSSA Vbn Vbn ISINK
x12[5] Vbn VSSA Vbn Vbn ISINK
x12[4] Vbn VSSA Vbn Vbn ISINK
x12[3] Vbn VSSA Vbn Vbn ISINK
x12[2] Vbn VSSA Vbn Vbn ISINK
x12[1] Vbn VSSA Vbn Vbn ISINK
x13[15] Vbn VSSA Vbn IOUT ISINK
x13[14] Vbn VSSA Vbn IOUT ISINK
x13[13] Vbn VSSA Vbn IOUT ISINK
x13[12] Vbn VSSA Vbn IOUT ISINK
x13[11] Vbn VSSA Vbn IOUT ISINK
x13[10] Vbn VSSA Vbn IOUT ISINK
x13[9] Vbn VSSA Vbn IOUT ISINK
x13[8] Vbn VSSA Vbn IOUT ISINK
x13[7] Vbn VSSA Vbn IOUT ISINK
x13[6] Vbn VSSA Vbn IOUT ISINK
x13[5] Vbn VSSA Vbn IOUT ISINK
x13[4] Vbn VSSA Vbn IOUT ISINK
x13[3] Vbn VSSA Vbn IOUT ISINK
x13[2] Vbn VSSA Vbn IOUT ISINK
x13[1] Vbn VSSA Vbn IOUT ISINK
XC1 VDDA IREF cap_mfringe w=28.0u l=44.0u mmin=1 mmax=4
.ends

* expanding   symbol:  DecadeDividerAux.sym # of pins=4
** sym_path: /foss/designs/ihp_INI_project/INI_Block/DecadeDividerAux.sym
** sch_path: /foss/designs/ihp_INI_project/INI_Block/DecadeDividerAux.sch
.subckt DecadeDividerAux VDDA VBIAS IREF_CORE[0] VSSA
*.iopin VSSA
*.iopin VDDA
*.iopin VBIAS
*.iopin IREF_CORE[0]
x1[20] VDDA VBIAS VBIAS VSSA IREF_CORE[0] ISOURCE
x1[19] VDDA VBIAS VBIAS VSSA IREF_CORE[0] ISOURCE
x1[18] VDDA VBIAS VBIAS VSSA IREF_CORE[0] ISOURCE
x1[17] VDDA VBIAS VBIAS VSSA IREF_CORE[0] ISOURCE
x1[16] VDDA VBIAS VBIAS VSSA IREF_CORE[0] ISOURCE
x1[15] VDDA VBIAS VBIAS VSSA IREF_CORE[0] ISOURCE
x1[14] VDDA VBIAS VBIAS VSSA IREF_CORE[0] ISOURCE
x1[13] VDDA VBIAS VBIAS VSSA IREF_CORE[0] ISOURCE
x1[12] VDDA VBIAS VBIAS VSSA IREF_CORE[0] ISOURCE
x1[11] VDDA VBIAS VBIAS VSSA IREF_CORE[0] ISOURCE
x1[10] VDDA VBIAS VBIAS VSSA IREF_CORE[0] ISOURCE
x1[9] VDDA VBIAS VBIAS VSSA IREF_CORE[0] ISOURCE
x1[8] VDDA VBIAS VBIAS VSSA IREF_CORE[0] ISOURCE
x1[7] VDDA VBIAS VBIAS VSSA IREF_CORE[0] ISOURCE
x1[6] VDDA VBIAS VBIAS VSSA IREF_CORE[0] ISOURCE
x1[5] VDDA VBIAS VBIAS VSSA IREF_CORE[0] ISOURCE
x1[4] VDDA VBIAS VBIAS VSSA IREF_CORE[0] ISOURCE
x1[3] VDDA VBIAS VBIAS VSSA IREF_CORE[0] ISOURCE
x1[2] VDDA VBIAS VBIAS VSSA IREF_CORE[0] ISOURCE
x1[1] VDDA VBIAS VBIAS VSSA IREF_CORE[0] ISOURCE
x2[20] VDDA VBIAS VBIAS VSSA IREF_CORE[1] ISOURCE
x2[19] VDDA VBIAS VBIAS VSSA IREF_CORE[1] ISOURCE
x2[18] VDDA VBIAS VBIAS VSSA IREF_CORE[1] ISOURCE
x2[17] VDDA VBIAS VBIAS VSSA IREF_CORE[1] ISOURCE
x2[16] VDDA VBIAS VBIAS VSSA IREF_CORE[1] ISOURCE
x2[15] VDDA VBIAS VBIAS VSSA IREF_CORE[1] ISOURCE
x2[14] VDDA VBIAS VBIAS VSSA IREF_CORE[1] ISOURCE
x2[13] VDDA VBIAS VBIAS VSSA IREF_CORE[1] ISOURCE
x2[12] VDDA VBIAS VBIAS VSSA IREF_CORE[1] ISOURCE
x2[11] VDDA VBIAS VBIAS VSSA IREF_CORE[1] ISOURCE
x2[10] VDDA VBIAS VBIAS VSSA IREF_CORE[1] ISOURCE
x2[9] VDDA VBIAS VBIAS VSSA IREF_CORE[1] ISOURCE
x2[8] VDDA VBIAS VBIAS VSSA IREF_CORE[1] ISOURCE
x2[7] VDDA VBIAS VBIAS VSSA IREF_CORE[1] ISOURCE
x2[6] VDDA VBIAS VBIAS VSSA IREF_CORE[1] ISOURCE
x2[5] VDDA VBIAS VBIAS VSSA IREF_CORE[1] ISOURCE
x2[4] VDDA VBIAS VBIAS VSSA IREF_CORE[1] ISOURCE
x2[3] VDDA VBIAS VBIAS VSSA IREF_CORE[1] ISOURCE
x2[2] VDDA VBIAS VBIAS VSSA IREF_CORE[1] ISOURCE
x2[1] VDDA VBIAS VBIAS VSSA IREF_CORE[1] ISOURCE
x3[20] VDDA VBIAS VBIAS VSSA IREF_CORE[2] ISOURCE
x3[19] VDDA VBIAS VBIAS VSSA IREF_CORE[2] ISOURCE
x3[18] VDDA VBIAS VBIAS VSSA IREF_CORE[2] ISOURCE
x3[17] VDDA VBIAS VBIAS VSSA IREF_CORE[2] ISOURCE
x3[16] VDDA VBIAS VBIAS VSSA IREF_CORE[2] ISOURCE
x3[15] VDDA VBIAS VBIAS VSSA IREF_CORE[2] ISOURCE
x3[14] VDDA VBIAS VBIAS VSSA IREF_CORE[2] ISOURCE
x3[13] VDDA VBIAS VBIAS VSSA IREF_CORE[2] ISOURCE
x3[12] VDDA VBIAS VBIAS VSSA IREF_CORE[2] ISOURCE
x3[11] VDDA VBIAS VBIAS VSSA IREF_CORE[2] ISOURCE
x3[10] VDDA VBIAS VBIAS VSSA IREF_CORE[2] ISOURCE
x3[9] VDDA VBIAS VBIAS VSSA IREF_CORE[2] ISOURCE
x3[8] VDDA VBIAS VBIAS VSSA IREF_CORE[2] ISOURCE
x3[7] VDDA VBIAS VBIAS VSSA IREF_CORE[2] ISOURCE
x3[6] VDDA VBIAS VBIAS VSSA IREF_CORE[2] ISOURCE
x3[5] VDDA VBIAS VBIAS VSSA IREF_CORE[2] ISOURCE
x3[4] VDDA VBIAS VBIAS VSSA IREF_CORE[2] ISOURCE
x3[3] VDDA VBIAS VBIAS VSSA IREF_CORE[2] ISOURCE
x3[2] VDDA VBIAS VBIAS VSSA IREF_CORE[2] ISOURCE
x3[1] VDDA VBIAS VBIAS VSSA IREF_CORE[2] ISOURCE
x4[20] VDDA VBIAS VBIAS VSSA IREF_CORE[3] ISOURCE
x4[19] VDDA VBIAS VBIAS VSSA IREF_CORE[3] ISOURCE
x4[18] VDDA VBIAS VBIAS VSSA IREF_CORE[3] ISOURCE
x4[17] VDDA VBIAS VBIAS VSSA IREF_CORE[3] ISOURCE
x4[16] VDDA VBIAS VBIAS VSSA IREF_CORE[3] ISOURCE
x4[15] VDDA VBIAS VBIAS VSSA IREF_CORE[3] ISOURCE
x4[14] VDDA VBIAS VBIAS VSSA IREF_CORE[3] ISOURCE
x4[13] VDDA VBIAS VBIAS VSSA IREF_CORE[3] ISOURCE
x4[12] VDDA VBIAS VBIAS VSSA IREF_CORE[3] ISOURCE
x4[11] VDDA VBIAS VBIAS VSSA IREF_CORE[3] ISOURCE
x4[10] VDDA VBIAS VBIAS VSSA IREF_CORE[3] ISOURCE
x4[9] VDDA VBIAS VBIAS VSSA IREF_CORE[3] ISOURCE
x4[8] VDDA VBIAS VBIAS VSSA IREF_CORE[3] ISOURCE
x4[7] VDDA VBIAS VBIAS VSSA IREF_CORE[3] ISOURCE
x4[6] VDDA VBIAS VBIAS VSSA IREF_CORE[3] ISOURCE
x4[5] VDDA VBIAS VBIAS VSSA IREF_CORE[3] ISOURCE
x4[4] VDDA VBIAS VBIAS VSSA IREF_CORE[3] ISOURCE
x4[3] VDDA VBIAS VBIAS VSSA IREF_CORE[3] ISOURCE
x4[2] VDDA VBIAS VBIAS VSSA IREF_CORE[3] ISOURCE
x4[1] VDDA VBIAS VBIAS VSSA IREF_CORE[3] ISOURCE
x5[20] VDDA VBIAS VBIAS VSSA IREF_CORE[4] ISOURCE
x5[19] VDDA VBIAS VBIAS VSSA IREF_CORE[4] ISOURCE
x5[18] VDDA VBIAS VBIAS VSSA IREF_CORE[4] ISOURCE
x5[17] VDDA VBIAS VBIAS VSSA IREF_CORE[4] ISOURCE
x5[16] VDDA VBIAS VBIAS VSSA IREF_CORE[4] ISOURCE
x5[15] VDDA VBIAS VBIAS VSSA IREF_CORE[4] ISOURCE
x5[14] VDDA VBIAS VBIAS VSSA IREF_CORE[4] ISOURCE
x5[13] VDDA VBIAS VBIAS VSSA IREF_CORE[4] ISOURCE
x5[12] VDDA VBIAS VBIAS VSSA IREF_CORE[4] ISOURCE
x5[11] VDDA VBIAS VBIAS VSSA IREF_CORE[4] ISOURCE
x5[10] VDDA VBIAS VBIAS VSSA IREF_CORE[4] ISOURCE
x5[9] VDDA VBIAS VBIAS VSSA IREF_CORE[4] ISOURCE
x5[8] VDDA VBIAS VBIAS VSSA IREF_CORE[4] ISOURCE
x5[7] VDDA VBIAS VBIAS VSSA IREF_CORE[4] ISOURCE
x5[6] VDDA VBIAS VBIAS VSSA IREF_CORE[4] ISOURCE
x5[5] VDDA VBIAS VBIAS VSSA IREF_CORE[4] ISOURCE
x5[4] VDDA VBIAS VBIAS VSSA IREF_CORE[4] ISOURCE
x5[3] VDDA VBIAS VBIAS VSSA IREF_CORE[4] ISOURCE
x5[2] VDDA VBIAS VBIAS VSSA IREF_CORE[4] ISOURCE
x5[1] VDDA VBIAS VBIAS VSSA IREF_CORE[4] ISOURCE
x6[20] VDDA VBIAS VBIAS VSSA IREF_CORE[5] ISOURCE
x6[19] VDDA VBIAS VBIAS VSSA IREF_CORE[5] ISOURCE
x6[18] VDDA VBIAS VBIAS VSSA IREF_CORE[5] ISOURCE
x6[17] VDDA VBIAS VBIAS VSSA IREF_CORE[5] ISOURCE
x6[16] VDDA VBIAS VBIAS VSSA IREF_CORE[5] ISOURCE
x6[15] VDDA VBIAS VBIAS VSSA IREF_CORE[5] ISOURCE
x6[14] VDDA VBIAS VBIAS VSSA IREF_CORE[5] ISOURCE
x6[13] VDDA VBIAS VBIAS VSSA IREF_CORE[5] ISOURCE
x6[12] VDDA VBIAS VBIAS VSSA IREF_CORE[5] ISOURCE
x6[11] VDDA VBIAS VBIAS VSSA IREF_CORE[5] ISOURCE
x6[10] VDDA VBIAS VBIAS VSSA IREF_CORE[5] ISOURCE
x6[9] VDDA VBIAS VBIAS VSSA IREF_CORE[5] ISOURCE
x6[8] VDDA VBIAS VBIAS VSSA IREF_CORE[5] ISOURCE
x6[7] VDDA VBIAS VBIAS VSSA IREF_CORE[5] ISOURCE
x6[6] VDDA VBIAS VBIAS VSSA IREF_CORE[5] ISOURCE
x6[5] VDDA VBIAS VBIAS VSSA IREF_CORE[5] ISOURCE
x6[4] VDDA VBIAS VBIAS VSSA IREF_CORE[5] ISOURCE
x6[3] VDDA VBIAS VBIAS VSSA IREF_CORE[5] ISOURCE
x6[2] VDDA VBIAS VBIAS VSSA IREF_CORE[5] ISOURCE
x6[1] VDDA VBIAS VBIAS VSSA IREF_CORE[5] ISOURCE
x7[20] VDDA VBIAS VBIAS VSSA IREF_CORE[6] ISOURCE
x7[19] VDDA VBIAS VBIAS VSSA IREF_CORE[6] ISOURCE
x7[18] VDDA VBIAS VBIAS VSSA IREF_CORE[6] ISOURCE
x7[17] VDDA VBIAS VBIAS VSSA IREF_CORE[6] ISOURCE
x7[16] VDDA VBIAS VBIAS VSSA IREF_CORE[6] ISOURCE
x7[15] VDDA VBIAS VBIAS VSSA IREF_CORE[6] ISOURCE
x7[14] VDDA VBIAS VBIAS VSSA IREF_CORE[6] ISOURCE
x7[13] VDDA VBIAS VBIAS VSSA IREF_CORE[6] ISOURCE
x7[12] VDDA VBIAS VBIAS VSSA IREF_CORE[6] ISOURCE
x7[11] VDDA VBIAS VBIAS VSSA IREF_CORE[6] ISOURCE
x7[10] VDDA VBIAS VBIAS VSSA IREF_CORE[6] ISOURCE
x7[9] VDDA VBIAS VBIAS VSSA IREF_CORE[6] ISOURCE
x7[8] VDDA VBIAS VBIAS VSSA IREF_CORE[6] ISOURCE
x7[7] VDDA VBIAS VBIAS VSSA IREF_CORE[6] ISOURCE
x7[6] VDDA VBIAS VBIAS VSSA IREF_CORE[6] ISOURCE
x7[5] VDDA VBIAS VBIAS VSSA IREF_CORE[6] ISOURCE
x7[4] VDDA VBIAS VBIAS VSSA IREF_CORE[6] ISOURCE
x7[3] VDDA VBIAS VBIAS VSSA IREF_CORE[6] ISOURCE
x7[2] VDDA VBIAS VBIAS VSSA IREF_CORE[6] ISOURCE
x7[1] VDDA VBIAS VBIAS VSSA IREF_CORE[6] ISOURCE
x8[20] VDDA VBIAS VBIAS VSSA IREF_CORE[7] ISOURCE
x8[19] VDDA VBIAS VBIAS VSSA IREF_CORE[7] ISOURCE
x8[18] VDDA VBIAS VBIAS VSSA IREF_CORE[7] ISOURCE
x8[17] VDDA VBIAS VBIAS VSSA IREF_CORE[7] ISOURCE
x8[16] VDDA VBIAS VBIAS VSSA IREF_CORE[7] ISOURCE
x8[15] VDDA VBIAS VBIAS VSSA IREF_CORE[7] ISOURCE
x8[14] VDDA VBIAS VBIAS VSSA IREF_CORE[7] ISOURCE
x8[13] VDDA VBIAS VBIAS VSSA IREF_CORE[7] ISOURCE
x8[12] VDDA VBIAS VBIAS VSSA IREF_CORE[7] ISOURCE
x8[11] VDDA VBIAS VBIAS VSSA IREF_CORE[7] ISOURCE
x8[10] VDDA VBIAS VBIAS VSSA IREF_CORE[7] ISOURCE
x8[9] VDDA VBIAS VBIAS VSSA IREF_CORE[7] ISOURCE
x8[8] VDDA VBIAS VBIAS VSSA IREF_CORE[7] ISOURCE
x8[7] VDDA VBIAS VBIAS VSSA IREF_CORE[7] ISOURCE
x8[6] VDDA VBIAS VBIAS VSSA IREF_CORE[7] ISOURCE
x8[5] VDDA VBIAS VBIAS VSSA IREF_CORE[7] ISOURCE
x8[4] VDDA VBIAS VBIAS VSSA IREF_CORE[7] ISOURCE
x8[3] VDDA VBIAS VBIAS VSSA IREF_CORE[7] ISOURCE
x8[2] VDDA VBIAS VBIAS VSSA IREF_CORE[7] ISOURCE
x8[1] VDDA VBIAS VBIAS VSSA IREF_CORE[7] ISOURCE
x9[20] VDDA VBIAS VBIAS VSSA IREF_CORE[8] ISOURCE
x9[19] VDDA VBIAS VBIAS VSSA IREF_CORE[8] ISOURCE
x9[18] VDDA VBIAS VBIAS VSSA IREF_CORE[8] ISOURCE
x9[17] VDDA VBIAS VBIAS VSSA IREF_CORE[8] ISOURCE
x9[16] VDDA VBIAS VBIAS VSSA IREF_CORE[8] ISOURCE
x9[15] VDDA VBIAS VBIAS VSSA IREF_CORE[8] ISOURCE
x9[14] VDDA VBIAS VBIAS VSSA IREF_CORE[8] ISOURCE
x9[13] VDDA VBIAS VBIAS VSSA IREF_CORE[8] ISOURCE
x9[12] VDDA VBIAS VBIAS VSSA IREF_CORE[8] ISOURCE
x9[11] VDDA VBIAS VBIAS VSSA IREF_CORE[8] ISOURCE
x9[10] VDDA VBIAS VBIAS VSSA IREF_CORE[8] ISOURCE
x9[9] VDDA VBIAS VBIAS VSSA IREF_CORE[8] ISOURCE
x9[8] VDDA VBIAS VBIAS VSSA IREF_CORE[8] ISOURCE
x9[7] VDDA VBIAS VBIAS VSSA IREF_CORE[8] ISOURCE
x9[6] VDDA VBIAS VBIAS VSSA IREF_CORE[8] ISOURCE
x9[5] VDDA VBIAS VBIAS VSSA IREF_CORE[8] ISOURCE
x9[4] VDDA VBIAS VBIAS VSSA IREF_CORE[8] ISOURCE
x9[3] VDDA VBIAS VBIAS VSSA IREF_CORE[8] ISOURCE
x9[2] VDDA VBIAS VBIAS VSSA IREF_CORE[8] ISOURCE
x9[1] VDDA VBIAS VBIAS VSSA IREF_CORE[8] ISOURCE
XC1 VDDA VBIAS cap_mfringe w=60.0u l=30.0u mmin=1 mmax=4
.ends

* expanding   symbol:  inv_BG.sym # of pins=4
** sym_path: /foss/designs/ihp_INI_project/INI_Block/inv_BG.sym
** sch_path: /foss/designs/ihp_INI_project/INI_Block/inv_BG.sch
.subckt inv_BG vdda out in vssa
*.ipin in
*.opin out
*.iopin vssa
*.iopin vdda
XM1 out in vdda vdda sg13_hv_pmos w=1u l=0.5u ng=1
XM2 out in vssa vssa sg13_hv_nmos w=1u l=0.5u ng=1
.ends

* expanding   symbol:  ISINK.sym # of pins=4
** sym_path: /foss/designs/ihp_INI_project/INI_Block/ISINK.sym
** sch_path: /foss/designs/ihp_INI_project/INI_Block/ISINK.sch
.subckt ISINK bias_VN vssa en_VS io_UN
*.ipin en_VS
*.iopin vssa
*.ipin bias_VN
*.iopin io_UN
XM1 io_UN en_VS net2 vssa sg13_hv_nmos w=2.5u l=0.5u ng=1
XM2 net2 bias_VN net1 vssa sg13_hv_nmos w=1u l=4u ng=1
XM3 net1 bias_VN vssa vssa sg13_hv_nmos w=1u l=4u ng=1
.ends

* expanding   symbol:  CoreFineDAC_N.sym # of pins=7
** sym_path: /foss/designs/ihp_INI_project/INI_Block/CoreFineDAC_N.sym
** sch_path: /foss/designs/ihp_INI_project/INI_Block/CoreFineDAC_N.sch
.subckt CoreFineDAC_N en_VS[10] en_VS[9] en_VS[8] en_VS[7] en_VS[6] en_VS[5] en_VS[4] en_VS[3] en_VS[2] en_VS[1] en_VS[0] vssa
+ vdda bias_VP bias_VN MASTER_CoreDiodeT_bias_VN[7] MASTER_CoreDiodeT_bias_VN[6] MASTER_CoreDiodeT_bias_VN[5]
+ MASTER_CoreDiodeT_bias_VN[4] MASTER_CoreDiodeT_bias_VN[3] MASTER_CoreDiodeT_bias_VN[2] MASTER_CoreDiodeT_bias_VN[1] MASTER_CoreDiodeT_bias_VN[0] BIASGEN_en_VS
*.ipin
*+ MASTER_CoreDiodeT_bias_VN[7],MASTER_CoreDiodeT_bias_VN[6],MASTER_CoreDiodeT_bias_VN[5],MASTER_CoreDiodeT_bias_VN[4],MASTER_CoreDiodeT_bias_VN[3],MASTER_CoreDiodeT_bias_VN[2],MASTER_CoreDiodeT_bias_VN[1],MASTER_CoreDiodeT_bias_VN[0]
*.ipin en_VS[10],en_VS[9],en_VS[8],en_VS[7],en_VS[6],en_VS[5],en_VS[4],en_VS[3],en_VS[2],en_VS[1],en_VS[0]
*.iopin vssa
*.iopin vdda
*.iopin bias_VP
*.iopin bias_VN
*.ipin BIASGEN_en_VS
xinv[10] vdda en_VSB[10] en_VS[10] vssa inv_BG
xinv[9] vdda en_VSB[9] en_VS[9] vssa inv_BG
xinv[8] vdda en_VSB[8] en_VS[8] vssa inv_BG
xinv[7] vdda en_VSB[7] en_VS[7] vssa inv_BG
xinv[6] vdda en_VSB[6] en_VS[6] vssa inv_BG
xinv[5] vdda en_VSB[5] en_VS[5] vssa inv_BG
xinv[4] vdda en_VSB[4] en_VS[4] vssa inv_BG
xinv[3] vdda en_VSB[3] en_VS[3] vssa inv_BG
xinv[2] vdda en_VSB[2] en_VS[2] vssa inv_BG
xinv[1] vdda en_VSB[1] en_VS[1] vssa inv_BG
xinv[0] vdda en_VSB[0] en_VS[0] vssa inv_BG
x1 MASTER_CoreDiodeT_bias_VN[7] MASTER_CoreDiodeT_bias_VN[6] MASTER_CoreDiodeT_bias_VN[5] MASTER_CoreDiodeT_bias_VN[4]
+ MASTER_CoreDiodeT_bias_VN[3] MASTER_CoreDiodeT_bias_VN[2] MASTER_CoreDiodeT_bias_VN[1] MASTER_CoreDiodeT_bias_VN[0] vssa en_VS[10] en_VS[9] en_VS[8]
+ en_VSB[10] en_VSB[9] en_VSB[8] MASTER_biasout_VN SelMUX
xisink0[2] MASTER_biasout_VN vssa BIASGEN_en_VS net1 ISINK
xisink0[1] MASTER_biasout_VN vssa BIASGEN_en_VS net1 ISINK
XM1 net1 net1 vdda vdda sg13_hv_pmos w=2u l=1u ng=2 m=2
XM2 bias_test net1 vdda vdda sg13_hv_pmos w=2u l=1u ng=2 m=2
x4 en_VS[0] net7 net2 en_VSB[0] bias_test vssa vdda bias_VP SplitterCell
XM_enb vdda vdda net3 vssa sg13_hv_nmos w=1u l=1u ng=1
XM_s9 net2 bias_test net8 vssa sg13_hv_nmos w=2u l=10u ng=1
XM_s10 net8 bias_test net9 vssa sg13_hv_nmos w=2u l=10u ng=1
XM_s11 net9 bias_test net10 vssa sg13_hv_nmos w=2u l=10u ng=1
XM_s12 net10 bias_test net3 vssa sg13_hv_nmos w=2u l=10u ng=1
x5 en_VS[1] net11 net7 en_VSB[1] bias_test vssa vdda bias_VP SplitterCell
x6 en_VS[2] net12 net11 en_VSB[2] bias_test vssa vdda bias_VP SplitterCell
x7 en_VS[3] net13 net12 en_VSB[3] bias_test vssa vdda bias_VP SplitterCell
x8 en_VS[4] net14 net13 en_VSB[4] bias_test vssa vdda bias_VP SplitterCell
x9 en_VS[5] net15 net14 en_VSB[5] bias_test vssa vdda bias_VP SplitterCell
x10 en_VS[6] net16 net15 en_VSB[6] bias_test vssa vdda bias_VP SplitterCell
x11 en_VS[7] V_drain_ISINK net16 en_VSB[7] bias_test vssa vdda bias_VP SplitterCell
XM8 net4 bias_VP vdda vdda sg13_hv_pmos w=4u l=1u ng=1 m=2
XM7 net5 bias_VP vdda vdda sg13_hv_pmos w=4u l=1u ng=1 m=2
XM9 bias_VP MASTER_CoreDiodeT_bias_VN[2] net4 vdda sg13_hv_pmos w=4u l=0.5u ng=1 m=2
XM10 bias_VN MASTER_CoreDiodeT_bias_VN[2] net5 vdda sg13_hv_pmos w=4u l=0.5u ng=1 m=2
xisink2[2] bias_VN vssa BIASGEN_en_VS bias_VN ISINK
xisink2[1] bias_VN vssa BIASGEN_en_VS bias_VN ISINK
XM_b4 bias_test bias_test net6 vssa sg13_hv_nmos w=2u l=6u ng=1
xisink1[8] MASTER_biasout_VN vssa BIASGEN_en_VS V_drain_ISINK ISINK
xisink1[7] MASTER_biasout_VN vssa BIASGEN_en_VS V_drain_ISINK ISINK
xisink1[6] MASTER_biasout_VN vssa BIASGEN_en_VS V_drain_ISINK ISINK
xisink1[5] MASTER_biasout_VN vssa BIASGEN_en_VS V_drain_ISINK ISINK
xisink1[4] MASTER_biasout_VN vssa BIASGEN_en_VS V_drain_ISINK ISINK
xisink1[3] MASTER_biasout_VN vssa BIASGEN_en_VS V_drain_ISINK ISINK
xisink1[2] MASTER_biasout_VN vssa BIASGEN_en_VS V_drain_ISINK ISINK
xisink1[1] MASTER_biasout_VN vssa BIASGEN_en_VS V_drain_ISINK ISINK
XM_b3 net6 net6 vssa vssa sg13_hv_nmos w=2u l=6u ng=1
XC3 vdda bias_VP cap_mfringe w=20.0u l=40.0u mmin=1 mmax=4
XC4 bias_VN vssa cap_mfringe w=20.0u l=40.0u mmin=1 mmax=4
.ends

* expanding   symbol:  ISOURCE.sym # of pins=5
** sym_path: /foss/designs/ihp_INI_project/INI_Block/ISOURCE.sym
** sch_path: /foss/designs/ihp_INI_project/INI_Block/ISOURCE.sch
.subckt ISOURCE VDDA MBIAS ENB VSSA IO
*.iopin VDDA
*.ipin MBIAS
*.ipin ENB
*.iopin IO
*.iopin VSSA
XM2 net1 MBIAS VDDA VDDA sg13_hv_pmos w=1u l=5u ng=1
XM1 IO ENB net1 VDDA sg13_hv_pmos w=3.3u l=0.5u ng=1
.ends

* expanding   symbol:  SelMUX.sym # of pins=5
** sym_path: /foss/designs/ihp_INI_project/INI_Block/SelMUX.sym
** sch_path: /foss/designs/ihp_INI_project/INI_Block/SelMUX.sch
.subckt SelMUX MASTER_bias_VN[7] MASTER_bias_VN[6] MASTER_bias_VN[5] MASTER_bias_VN[4] MASTER_bias_VN[3] MASTER_bias_VN[2]
+ MASTER_bias_VN[1] MASTER_bias_VN[0] vssa en_VS[2] en_VS[1] en_VS[0] en_VSB[2] en_VSB[1] en_VSB[0] MASTER_biasout_VN
*.ipin
*+ MASTER_bias_VN[7],MASTER_bias_VN[6],MASTER_bias_VN[5],MASTER_bias_VN[4],MASTER_bias_VN[3],MASTER_bias_VN[2],MASTER_bias_VN[1],MASTER_bias_VN[0]
*.opin MASTER_biasout_VN
*.ipin en_VS[2],en_VS[1],en_VS[0]
*.ipin en_VSB[2],en_VSB[1],en_VSB[0]
*.iopin vssa
XMUX_L0_0 MASTER_bias_VN[7] en_VS[0] net1 vssa sg13_hv_nmos w=4.98u l=0.45u ng=6
XMUX_L0_1 MASTER_bias_VN[6] en_VSB[0] net1 vssa sg13_hv_nmos w=0.45u l=10u ng=1
XMUX_L0_2 MASTER_bias_VN[5] en_VS[0] net2 vssa sg13_hv_nmos w=0.45u l=10u ng=1
XMUX_L0_3 MASTER_bias_VN[4] en_VSB[0] net2 vssa sg13_hv_nmos w=0.45u l=10u ng=1
XMUX_L0_4 MASTER_bias_VN[3] en_VS[0] net3 vssa sg13_hv_nmos w=0.45u l=10u ng=1
XMUX_L0_5 MASTER_bias_VN[2] en_VSB[0] net3 vssa sg13_hv_nmos w=0.45u l=10u ng=1
XMUX_L0_6 MASTER_bias_VN[1] en_VS[0] net4 vssa sg13_hv_nmos w=0.45u l=10u ng=1
XMUX_L0_7 MASTER_bias_VN[0] en_VSB[0] net4 vssa sg13_hv_nmos w=0.45u l=10u ng=1
XMUX_L1_A net1 en_VS[1] net5 vssa sg13_hv_nmos w=4.98u l=0.45u ng=6
XMUX_L1_B net2 en_VSB[1] net5 vssa sg13_hv_nmos w=0.45u l=10u ng=1
XMUX_L1_C net3 en_VS[1] net6 vssa sg13_hv_nmos w=0.45u l=10u ng=1
XMUX_L1_D net4 en_VSB[1] net6 vssa sg13_hv_nmos w=0.45u l=10u ng=1
XMUX_L2_A net5 en_VS[2] MASTER_biasout_VN vssa sg13_hv_nmos w=5u l=0.45u ng=2
XMUX_L2_B net6 en_VSB[2] MASTER_biasout_VN vssa sg13_hv_nmos w=0.45u l=10u ng=1
.ends

* expanding   symbol:  SplitterCell.sym # of pins=9
** sym_path: /foss/designs/ihp_INI_project/INI_Block/SplitterCell.sym
** sch_path: /foss/designs/ihp_INI_project/INI_Block/SplitterCell.sch
.subckt SplitterCell en_VS A_UN B_UN en_VSB bias_VN vssa out_UPB out_UP
*.ipin en_VS
*.ipin en_VSB
*.ipin bias_VN
*.iopin B_UN
*.iopin out_UP
*.iopin out_UPB
*.iopin vssa
*.iopin A_UN
XM_en out_UP en_VS net1 vssa sg13_hv_nmos w=1u l=1u ng=1
XM_enb out_UPB en_VSB net1 vssa sg13_hv_nmos w=1u l=1u ng=1
XM_s1 net1 bias_VN net3 vssa sg13_hv_nmos w=2u l=10u ng=1
XM_s2 net3 bias_VN net4 vssa sg13_hv_nmos w=2u l=10u ng=1
XM_s3 net4 bias_VN net5 vssa sg13_hv_nmos w=2u l=10u ng=1
XM_s4 net5 bias_VN net2 vssa sg13_hv_nmos w=2u l=10u ng=1
XM_s5 net2 bias_VN net6 vssa sg13_hv_nmos w=2u l=10u ng=1
XM_s6 net6 bias_VN net7 vssa sg13_hv_nmos w=2u l=10u ng=1
XM_s7 net7 bias_VN net8 vssa sg13_hv_nmos w=2u l=10u ng=1
XM_s8 net8 bias_VN A_UN vssa sg13_hv_nmos w=2u l=10u ng=1
XM_s9 A_UN bias_VN net9 vssa sg13_hv_nmos w=2u l=10u ng=1
XM_s10 net9 bias_VN net10 vssa sg13_hv_nmos w=2u l=10u ng=1
XM_s11 net10 bias_VN net11 vssa sg13_hv_nmos w=2u l=10u ng=1
XM_s12 net11 bias_VN B_UN vssa sg13_hv_nmos w=2u l=10u ng=1
.ends

.end
