** sch_path: /foss/designs/ihp_INI_project/INI_Block/INI_Block.sch
.subckt INI_Block SPI_CS_N SPI_MISO SPI_SCK SPI_MOSI SPI_RST_N VSS VDD MEM_bufferbias C2F_REQ C2F_COMP C2F_ACK NN1_REQ NN2_REQ
+ NN3_REQ NN1_ACK NN2_ACK NN3_ACK V2I_INN V2I_INP NN1_MEM_PROB NN2_MEM_PROB NN3_MEM_PROB BG_100mV BG_BIAS BG_100kRES BG_PROB
*.PININFO SPI_CS_N:I SPI_MISO:O SPI_SCK:I SPI_MOSI:I SPI_RST_N:I VSS:B VDD:B MEM_bufferbias:I C2F_REQ:O C2F_COMP:O C2F_ACK:I
*+ NN1_REQ:O NN2_REQ:O NN3_REQ:O NN1_ACK:I NN2_ACK:I NN3_ACK:I V2I_INN:I V2I_INP:I NN1_MEM_PROB:O NN2_MEM_PROB:O NN3_MEM_PROB:O BG_100mV:I
*+ BG_BIAS:I BG_100kRES:I BG_PROB:O
xspi SPI_CS_N SPI_MISO mosi SPI_RST_N SPI_SCK VDD bias_gen_spi_top
* noconn #net1
* noconn #net4
xiniblockanalog BIASGEN_en_VS[10] BIASGEN_en_VS[9] BIASGEN_en_VS[8] BIASGEN_en_VS[7] BIASGEN_en_VS[6] BIASGEN_en_VS[5]
+ BIASGEN_en_VS[4] BIASGEN_en_VS[3] BIASGEN_en_VS[2] BIASGEN_en_VS[1] BIASGEN_en_VS[0] BIASGEN_BYP_en_VS[10] BIASGEN_BYP_en_VS[9]
+ BIASGEN_BYP_en_VS[8] BIASGEN_BYP_en_VS[7] BIASGEN_BYP_en_VS[6] BIASGEN_BYP_en_VS[5] BIASGEN_BYP_en_VS[4] BIASGEN_BYP_en_VS[3] BIASGEN_BYP_en_VS[2]
+ BIASGEN_BYP_en_VS[1] BIASGEN_BYP_en_VS[0] BIASGEN_EXT_REF_en_VS[10] BIASGEN_EXT_REF_en_VS[9] BIASGEN_EXT_REF_en_VS[8] BIASGEN_EXT_REF_en_VS[7]
+ BIASGEN_EXT_REF_en_VS[6] BIASGEN_EXT_REF_en_VS[5] BIASGEN_EXT_REF_en_VS[4] BIASGEN_EXT_REF_en_VS[3] BIASGEN_EXT_REF_en_VS[2] BIASGEN_EXT_REF_en_VS[1]
+ BIASGEN_EXT_REF_en_VS[0] en_VS_7[10] en_VS_7[9] en_VS_7[8] en_VS_7[7] en_VS_7[6] en_VS_7[5] en_VS_7[4] en_VS_7[3] en_VS_7[2] en_VS_7[1] en_VS_7[0]
+ en_VS_9[10] en_VS_9[9] en_VS_9[8] en_VS_9[7] en_VS_9[6] en_VS_9[5] en_VS_9[4] en_VS_9[3] en_VS_9[2] en_VS_9[1] en_VS_9[0] en_VS_1[10]
+ en_VS_1[9] en_VS_1[8] en_VS_1[7] en_VS_1[6] en_VS_1[5] en_VS_1[4] en_VS_1[3] en_VS_1[2] en_VS_1[1] en_VS_1[0] en_VS_6[10] en_VS_6[9]
+ en_VS_6[8] en_VS_6[7] en_VS_6[6] en_VS_6[5] en_VS_6[4] en_VS_6[3] en_VS_6[2] en_VS_6[1] en_VS_6[0] en_VS_5[10] en_VS_5[9] en_VS_5[8]
+ en_VS_5[7] en_VS_5[6] en_VS_5[5] en_VS_5[4] en_VS_5[3] en_VS_5[2] en_VS_5[1] en_VS_5[0] en_VS_3[10] en_VS_3[9] en_VS_3[8] en_VS_3[7]
+ en_VS_3[6] en_VS_3[5] en_VS_3[4] en_VS_3[3] en_VS_3[2] en_VS_3[1] en_VS_3[0] en_VS_8[10] en_VS_8[9] en_VS_8[8] en_VS_8[7] en_VS_8[6]
+ en_VS_8[5] en_VS_8[4] en_VS_8[3] en_VS_8[2] en_VS_8[1] en_VS_8[0] en_VS_2[10] en_VS_2[9] en_VS_2[8] en_VS_2[7] en_VS_2[6] en_VS_2[5]
+ en_VS_2[4] en_VS_2[3] en_VS_2[2] en_VS_2[1] en_VS_2[0] en_VS_4[10] en_VS_4[9] en_VS_4[8] en_VS_4[7] en_VS_4[6] en_VS_4[5] en_VS_4[4]
+ en_VS_4[3] en_VS_4[2] en_VS_4[1] en_VS_4[0] BG_PROB NN2_MEM_PROB NN3_REQ NN3_ACK NN3_MEM_PROB NN2_REQ NN2_ACK VDD NN1_MEM_PROB V2I_INP
+ NN1_REQ V2I_INN BG_100kRES NN1_ACK VSS BG_BIAS BG_100mV C2F_REQ C2F_ACK C2F_COMP MEM_bufferbias INI_Block_analog
* noconn #net3
* noconn #net2
.ends

* expanding   symbol:  bias_gen_spi_top.sym # of pins=23
** sym_path: /foss/designs/ihp_INI_project/INI_Block/bias_gen_spi_top.sym
$ Spice netlist generated by v2lvs
$ v2021.3_35.19    Wed Sep 1 15:25:12 PDT 2021
.INCLUDE "./spice.inc"
*.BUSDELIMITER [

.SUBCKT bias_gen_spi_top cs_n miso mosi \reg_out10[0] \reg_out10[10]
+ \reg_out10[1] \reg_out10[2] \reg_out10[3] \reg_out10[4] \reg_out10[5]
+ \reg_out10[6] \reg_out10[7] \reg_out10[8] \reg_out10[9] \reg_out11[0]
+ \reg_out11[10] \reg_out11[1] \reg_out11[2] \reg_out11[3] \reg_out11[4]
+ \reg_out11[5] \reg_out11[6] \reg_out11[7] \reg_out11[8] \reg_out11[9]
+ \reg_out12[0] \reg_out12[10] \reg_out12[1] \reg_out12[2] \reg_out12[3]
+ \reg_out12[4] \reg_out12[5] \reg_out12[6] \reg_out12[7] \reg_out12[8]
+ \reg_out12[9] \reg_out13[0] \reg_out13[10] \reg_out13[1] \reg_out13[2]
+ \reg_out13[3] \reg_out13[4] \reg_out13[5] \reg_out13[6] \reg_out13[7]
+ \reg_out13[8] \reg_out13[9] \reg_out14[0] \reg_out14[10] \reg_out14[1]
+ \reg_out14[2] \reg_out14[3] \reg_out14[4] \reg_out14[5] \reg_out14[6]
+ \reg_out14[7] \reg_out14[8] \reg_out14[9] \reg_out15[0] \reg_out15[10]
+ \reg_out15[1] \reg_out15[2] \reg_out15[3] \reg_out15[4] \reg_out15[5]
+ \reg_out15[6] \reg_out15[7] \reg_out15[8] \reg_out15[9] \reg_out16[0]
+ \reg_out16[10] \reg_out16[1] \reg_out16[2] \reg_out16[3] \reg_out16[4]
+ \reg_out16[5] \reg_out16[6] \reg_out16[7] \reg_out16[8] \reg_out16[9]
+ \reg_out1[0] \reg_out1[10] \reg_out1[1] \reg_out1[2] \reg_out1[3]
+ \reg_out1[4] \reg_out1[5] \reg_out1[6] \reg_out1[7] \reg_out1[8] \reg_out1[9]
+ \reg_out2[0] \reg_out2[10] \reg_out2[1] \reg_out2[2] \reg_out2[3]
+ \reg_out2[4] \reg_out2[5] \reg_out2[6] \reg_out2[7] \reg_out2[8] \reg_out2[9]
+ \reg_out3[0] \reg_out3[10] \reg_out3[1] \reg_out3[2] \reg_out3[3]
+ \reg_out3[4] \reg_out3[5] \reg_out3[6] \reg_out3[7] \reg_out3[8] \reg_out3[9]
+ \reg_out4[0] \reg_out4[10] \reg_out4[1] \reg_out4[2] \reg_out4[3]
+ \reg_out4[4] \reg_out4[5] \reg_out4[6] \reg_out4[7] \reg_out4[8] \reg_out4[9]
+ \reg_out5[0] \reg_out5[10] \reg_out5[1] \reg_out5[2] \reg_out5[3]
+ \reg_out5[4] \reg_out5[5] \reg_out5[6] \reg_out5[7] \reg_out5[8] \reg_out5[9]
+ \reg_out6[0] \reg_out6[10] \reg_out6[1] \reg_out6[2] \reg_out6[3]
+ \reg_out6[4] \reg_out6[5] \reg_out6[6] \reg_out6[7] \reg_out6[8] \reg_out6[9]
+ \reg_out7[0] \reg_out7[10] \reg_out7[1] \reg_out7[2] \reg_out7[3]
+ \reg_out7[4] \reg_out7[5] \reg_out7[6] \reg_out7[7] \reg_out7[8] \reg_out7[9]
+ \reg_out8[0] \reg_out8[10] \reg_out8[1] \reg_out8[2] \reg_out8[3]
+ \reg_out8[4] \reg_out8[5] \reg_out8[6] \reg_out8[7] \reg_out8[8] \reg_out8[9]
+ \reg_out9[0] \reg_out9[10] \reg_out9[1] \reg_out9[2] \reg_out9[3]
+ \reg_out9[4] \reg_out9[5] \reg_out9[6] \reg_out9[7] \reg_out9[8] \reg_out9[9]
+ rst_n sck VDD VSS
X_0977_ sg13cmos5l_nor4_1 $PINS A=\u_spi_core.bit_cnt[1]
+ B=\u_spi_core.bit_cnt[0] C=\u_spi_core.bit_cnt[2] D=\u_spi_core.bit_cnt[3]
+ Y=_0555_ VDD=VDD VSS=VSS
X_0979_ sg13cmos5l_nor2b_1 $PINS A=\u_spi_core.bit_cnt[5]
+ B_N=\u_spi_core.bit_cnt[4] Y=_0557_ VDD=VDD VSS=VSS
X_0980_ sg13cmos5l_nand2_1 $PINS Y=_0558_ A=_0555_ B=_0557_ VDD=VDD VSS=VSS
X_0982_ sg13cmos5l_inv_1 $PINS VDD=VDD Y=_0560_ A=\bias_gen_reg_din[14] VSS=VSS
X_0983_ sg13cmos5l_nor3_1 $PINS A=_0560_ B=\bias_gen_reg_din[15]
+ C=\u_spi_core.shift_in[15] Y=_0561_ VDD=VDD VSS=VSS
X_0985_ sg13cmos5l_and2_1 $PINS A=_0555_ B=_0557_ X=_0563_ VDD=VDD VSS=VSS
X_0987_ sg13cmos5l_and3_1 $PINS X=_0565_ A=\u_spi_core.read_data[9] B=net355
+ C=net353 VDD=VDD VSS=VSS
X_0988_ sg13cmos5l_a21oi_1 $PINS VSS=VSS VDD=VDD A1=\u_spi_core.miso_shift[8]
+ A2=net356 Y=_0566_ B1=_0565_
X_0989_ sg13cmos5l_nand3b_1 $PINS B=\u_spi_core.bit_cnt[5] C=_0555_ Y=_0567_
+ VDD=VDD VSS=VSS A_N=\u_spi_core.bit_cnt[4]
X_0990_ sg13cmos5l_nand2b_1 $PINS Y=_0568_ B=_0567_ A_N=_0557_ VDD=VDD VSS=VSS
X_0992_ sg13cmos5l_nor2_1 $PINS A=\u_spi_core.miso_shift[9] B=net341 Y=_0570_
+ VDD=VDD VSS=VSS
X_0993_ sg13cmos5l_a21oi_1 $PINS VSS=VSS VDD=VDD A1=_0566_ A2=net341 Y=_0239_
+ B1=_0570_
X_0995_ sg13cmos5l_and3_1 $PINS X=_0572_ A=\u_spi_core.read_data[8] B=net355
+ C=net353 VDD=VDD VSS=VSS
X_0996_ sg13cmos5l_a21oi_1 $PINS VSS=VSS VDD=VDD A1=\u_spi_core.miso_shift[7]
+ A2=net356 Y=_0573_ B1=_0572_
X_0997_ sg13cmos5l_nor2_1 $PINS A=\u_spi_core.miso_shift[8] B=net340 Y=_0574_
+ VDD=VDD VSS=VSS
X_0998_ sg13cmos5l_a21oi_1 $PINS VSS=VSS VDD=VDD A1=net340 A2=_0573_ Y=_0238_
+ B1=_0574_
X_0999_ sg13cmos5l_and3_1 $PINS X=_0575_ A=\u_spi_core.read_data[7] B=net355
+ C=net353 VDD=VDD VSS=VSS
X_1000_ sg13cmos5l_a21oi_1 $PINS VSS=VSS VDD=VDD A1=\u_spi_core.miso_shift[6]
+ A2=net356 Y=_0576_ B1=_0575_
X_1001_ sg13cmos5l_nor2_1 $PINS A=\u_spi_core.miso_shift[7] B=net340 Y=_0577_
+ VDD=VDD VSS=VSS
X_1002_ sg13cmos5l_a21oi_1 $PINS VSS=VSS VDD=VDD A1=net340 A2=_0576_ Y=_0237_
+ B1=_0577_
X_1003_ sg13cmos5l_and3_1 $PINS X=_0578_ A=\u_spi_core.read_data[6] B=net355
+ C=net353 VDD=VDD VSS=VSS
X_1004_ sg13cmos5l_a21oi_1 $PINS VSS=VSS VDD=VDD A1=\u_spi_core.miso_shift[5]
+ A2=net356 Y=_0579_ B1=_0578_
X_1005_ sg13cmos5l_nor2_1 $PINS A=\u_spi_core.miso_shift[6] B=net340 Y=_0580_
+ VDD=VDD VSS=VSS
X_1006_ sg13cmos5l_a21oi_1 $PINS VSS=VSS VDD=VDD A1=net340 A2=_0579_ Y=_0236_
+ B1=_0580_
X_1007_ sg13cmos5l_and3_1 $PINS X=_0581_ A=\u_spi_core.read_data[5] B=net355
+ C=net353 VDD=VDD VSS=VSS
X_1008_ sg13cmos5l_a21oi_1 $PINS VSS=VSS VDD=VDD A1=\u_spi_core.miso_shift[4]
+ A2=net356 Y=_0582_ B1=_0581_
X_1010_ sg13cmos5l_nor2_1 $PINS A=\u_spi_core.miso_shift[5] B=net340 Y=_0584_
+ VDD=VDD VSS=VSS
X_1011_ sg13cmos5l_a21oi_1 $PINS VSS=VSS VDD=VDD A1=net340 A2=_0582_ Y=_0235_
+ B1=_0584_
X_1012_ sg13cmos5l_and3_1 $PINS X=_0585_ A=\u_spi_core.read_data[4] B=net355
+ C=net353 VDD=VDD VSS=VSS
X_1013_ sg13cmos5l_a21oi_1 $PINS VSS=VSS VDD=VDD A1=\u_spi_core.miso_shift[3]
+ A2=net356 Y=_0586_ B1=_0585_
X_1014_ sg13cmos5l_nor2_1 $PINS A=\u_spi_core.miso_shift[4] B=net341 Y=_0587_
+ VDD=VDD VSS=VSS
X_1015_ sg13cmos5l_a21oi_1 $PINS VSS=VSS VDD=VDD A1=net341 A2=_0586_ Y=_0234_
+ B1=_0587_
X_1016_ sg13cmos5l_and3_1 $PINS X=_0588_ A=\u_spi_core.read_data[3] B=_0561_
+ C=net354 VDD=VDD VSS=VSS
X_1017_ sg13cmos5l_a21oi_1 $PINS VSS=VSS VDD=VDD A1=\u_spi_core.miso_shift[2]
+ A2=_0558_ Y=_0589_ B1=_0588_
X_1018_ sg13cmos5l_nor2_1 $PINS A=\u_spi_core.miso_shift[3] B=net342 Y=_0590_
+ VDD=VDD VSS=VSS
X_1019_ sg13cmos5l_a21oi_1 $PINS VSS=VSS VDD=VDD A1=net342 A2=_0589_ Y=_0233_
+ B1=_0590_
X_1020_ sg13cmos5l_and3_1 $PINS X=_0591_ A=\u_spi_core.read_data[2] B=net355
+ C=net353 VDD=VDD VSS=VSS
X_1021_ sg13cmos5l_a21oi_1 $PINS VSS=VSS VDD=VDD A1=\u_spi_core.miso_shift[1]
+ A2=net356 Y=_0592_ B1=_0591_
X_1022_ sg13cmos5l_nor2_1 $PINS A=\u_spi_core.miso_shift[2] B=net342 Y=_0593_
+ VDD=VDD VSS=VSS
X_1023_ sg13cmos5l_a21oi_1 $PINS VSS=VSS VDD=VDD A1=net341 A2=_0592_ Y=_0232_
+ B1=_0593_
X_1024_ sg13cmos5l_and3_1 $PINS X=_0594_ A=\u_spi_core.read_data[1] B=_0561_
+ C=net354 VDD=VDD VSS=VSS
X_1025_ sg13cmos5l_a21oi_1 $PINS VSS=VSS VDD=VDD A1=\u_spi_core.miso_shift[0]
+ A2=_0558_ Y=_0595_ B1=_0594_
X_1026_ sg13cmos5l_nor2_1 $PINS A=\u_spi_core.miso_shift[1] B=net342 Y=_0596_
+ VDD=VDD VSS=VSS
X_1027_ sg13cmos5l_a21oi_1 $PINS VSS=VSS VDD=VDD A1=net342 A2=_0595_ Y=_0231_
+ B1=_0596_
X_1028_ sg13cmos5l_and3_1 $PINS X=_0597_ A=\u_spi_core.read_data[15] B=_0561_
+ C=net354 VDD=VDD VSS=VSS
X_1029_ sg13cmos5l_a21oi_1 $PINS VSS=VSS VDD=VDD A1=\u_spi_core.miso_shift[14]
+ A2=_0558_ Y=_0598_ B1=_0597_
X_1030_ sg13cmos5l_nor2_1 $PINS A=\u_spi_core.miso_shift[15] B=_0568_ Y=_0599_
+ VDD=VDD VSS=VSS
X_1031_ sg13cmos5l_a21oi_1 $PINS VSS=VSS VDD=VDD A1=_0568_ A2=_0598_ Y=_0230_
+ B1=_0599_
X_1032_ sg13cmos5l_and3_1 $PINS X=_0600_ A=\u_spi_core.read_data[14] B=_0561_
+ C=net354 VDD=VDD VSS=VSS
X_1033_ sg13cmos5l_a21oi_1 $PINS VSS=VSS VDD=VDD A1=\u_spi_core.miso_shift[13]
+ A2=_0558_ Y=_0601_ B1=_0600_
X_1034_ sg13cmos5l_nor2_1 $PINS A=\u_spi_core.miso_shift[14] B=net343 Y=_0602_
+ VDD=VDD VSS=VSS
X_1035_ sg13cmos5l_a21oi_1 $PINS VSS=VSS VDD=VDD A1=net343 A2=_0601_ Y=_0229_
+ B1=_0602_
X_1036_ sg13cmos5l_and3_1 $PINS X=_0603_ A=\u_spi_core.read_data[13] B=_0561_
+ C=net354 VDD=VDD VSS=VSS
X_1037_ sg13cmos5l_a21oi_1 $PINS VSS=VSS VDD=VDD A1=\u_spi_core.miso_shift[12]
+ A2=_0558_ Y=_0604_ B1=_0603_
X_1038_ sg13cmos5l_nor2_1 $PINS A=\u_spi_core.miso_shift[13] B=net343 Y=_0605_
+ VDD=VDD VSS=VSS
X_1039_ sg13cmos5l_a21oi_1 $PINS VSS=VSS VDD=VDD A1=net343 A2=_0604_ Y=_0228_
+ B1=_0605_
X_1040_ sg13cmos5l_and3_1 $PINS X=_0606_ A=\u_spi_core.read_data[12] B=_0561_
+ C=net354 VDD=VDD VSS=VSS
X_1041_ sg13cmos5l_a21oi_1 $PINS VSS=VSS VDD=VDD A1=\u_spi_core.miso_shift[11]
+ A2=_0558_ Y=_0607_ B1=_0606_
X_1042_ sg13cmos5l_nor2_1 $PINS A=\u_spi_core.miso_shift[12] B=net343 Y=_0608_
+ VDD=VDD VSS=VSS
X_1043_ sg13cmos5l_a21oi_1 $PINS VSS=VSS VDD=VDD A1=net343 A2=_0607_ Y=_0227_
+ B1=_0608_
X_1044_ sg13cmos5l_and3_1 $PINS X=_0609_ A=\u_spi_core.read_data[11] B=_0561_
+ C=net354 VDD=VDD VSS=VSS
X_1045_ sg13cmos5l_a21oi_1 $PINS VSS=VSS VDD=VDD A1=\u_spi_core.miso_shift[10]
+ A2=_0558_ Y=_0610_ B1=_0609_
X_1046_ sg13cmos5l_nor2_1 $PINS A=\u_spi_core.miso_shift[11] B=net343 Y=_0611_
+ VDD=VDD VSS=VSS
X_1047_ sg13cmos5l_a21oi_1 $PINS VSS=VSS VDD=VDD A1=net342 A2=_0610_ Y=_0226_
+ B1=_0611_
X_1048_ sg13cmos5l_and3_1 $PINS X=_0612_ A=\u_spi_core.read_data[10] B=net355
+ C=net353 VDD=VDD VSS=VSS
X_1049_ sg13cmos5l_a21oi_1 $PINS VSS=VSS VDD=VDD A1=\u_spi_core.miso_shift[9]
+ A2=net356 Y=_0613_ B1=_0612_
X_1050_ sg13cmos5l_nor2_1 $PINS A=\u_spi_core.miso_shift[10] B=net341 Y=_0614_
+ VDD=VDD VSS=VSS
X_1051_ sg13cmos5l_a21oi_1 $PINS VSS=VSS VDD=VDD A1=net341 A2=_0613_ Y=_0225_
+ B1=_0614_
X_1052_ sg13cmos5l_inv_1 $PINS VDD=VDD Y=_0615_ A=\u_spi_core.miso_shift[0]
+ VSS=VSS
X_1053_ sg13cmos5l_inv_1 $PINS VDD=VDD Y=_0616_ A=\u_spi_core.shift_in[15]
+ VSS=VSS
X_1054_ sg13cmos5l_mux2_1 $PINS A0=\u_spi_core.read_data[0]
+ A1=\u_spi_core.eoc_flag S=\bias_gen_reg_din[15] X=_0617_ VDD=VDD VSS=VSS
X_1055_ sg13cmos5l_nand4_1 $PINS B=_0616_ C=_0563_ A=\bias_gen_reg_din[14]
+ Y=_0618_ VDD=VDD VSS=VSS D=_0617_
X_1056_ sg13cmos5l_o21ai_1 $PINS B1=_0618_ VDD=VDD Y=_0224_ VSS=VSS A1=_0615_
+ A2=_0568_
X_1058_ sg13cmos5l_nor2b_2 $PINS A=cs_n B_N=rst_n Y=\u_spi_core.spi_rst_n
+ VDD=VDD VSS=VSS
X_1060_ sg13cmos5l_and3_1 $PINS X=_0621_ A=\u_spi_core.bit_cnt[1]
+ B=\u_spi_core.bit_cnt[2] C=\u_spi_core.bit_cnt[3] VDD=VDD VSS=VSS
X_1061_ sg13cmos5l_nand3_1 $PINS B=\u_spi_core.bit_cnt[0] C=_0621_
+ A=\u_spi_core.bit_cnt[4] Y=_0622_ VDD=VDD VSS=VSS
X_1062_ sg13cmos5l_nand2b_1 $PINS Y=_0272_ B=_0622_ A_N=net368 VDD=VDD VSS=VSS
X_1063_ sg13cmos5l_nor2b_1 $PINS A=cs_n B_N=\u_spi_core.miso_shift[15] Y=miso
+ VDD=VDD VSS=VSS
X_1064_ sg13cmos5l_nor2b_2 $PINS A=\u_spi_core.bit_cnt[5]
+ B_N=\u_spi_core.bit_cnt[0] Y=_0623_ VDD=VDD VSS=VSS
X_1065_ sg13cmos5l_nand2b_1 $PINS Y=_0624_ B=_0623_ A_N=cs_n VDD=VDD VSS=VSS
X_1066_ sg13cmos5l_nand2b_1 $PINS Y=_0625_ B=\bias_gen_reg_din[11]
+ A_N=\bias_gen_reg_din[12] VDD=VDD VSS=VSS
X_1067_ sg13cmos5l_nor2_1 $PINS A=\u_spi_core.bit_cnt[4]
+ B=\bias_gen_reg_din[13] Y=_0626_ VDD=VDD VSS=VSS
X_1068_ sg13cmos5l_nand3_1 $PINS B=\u_spi_core.bit_cnt[3] C=_0626_
+ A=\u_spi_core.bit_cnt[2] Y=_0627_ VDD=VDD VSS=VSS
X_1069_ sg13cmos5l_or4_1 $PINS A=\u_spi_core.bit_cnt[1] B=_0624_ C=_0625_
+ D=_0627_ X=_0628_ VDD=VDD VSS=VSS
X_1070_ sg13cmos5l_inv_1 $PINS VDD=VDD Y=_0629_ A=_0628_ VSS=VSS
X_1076_ sg13cmos5l_mux2_1 $PINS A0=\bias_gen_reg_din[9] A1=net401 S=net365
+ X=_0016_ VDD=VDD VSS=VSS
X_1077_ sg13cmos5l_mux2_1 $PINS A0=net401 A1=\bias_gen_reg_din[11] S=net364
+ X=_0017_ VDD=VDD VSS=VSS
X_1078_ sg13cmos5l_mux2_1 $PINS A0=\bias_gen_reg_din[11]
+ A1=\bias_gen_reg_din[12] S=net368 X=_0018_ VDD=VDD VSS=VSS
X_1079_ sg13cmos5l_mux2_1 $PINS A0=\bias_gen_reg_din[12]
+ A1=\bias_gen_reg_din[13] S=net367 X=_0019_ VDD=VDD VSS=VSS
X_1081_ sg13cmos5l_mux2_1 $PINS A0=\bias_gen_reg_din[13]
+ A1=\bias_gen_reg_din[14] S=net367 X=_0020_ VDD=VDD VSS=VSS
X_1082_ sg13cmos5l_nand2_1 $PINS Y=_0635_ A=\bias_gen_reg_din[15] B=net367
+ VDD=VDD VSS=VSS
X_1083_ sg13cmos5l_o21ai_1 $PINS B1=_0635_ VDD=VDD Y=_0021_ VSS=VSS A1=_0560_
+ A2=net367
X_1088_ sg13cmos5l_mux2_1 $PINS A0=mosi A1=\bias_gen_reg_din[1] S=net364
+ X=_0022_ VDD=VDD VSS=VSS
X_1092_ sg13cmos5l_mux2_1 $PINS A0=\bias_gen_reg_din[1] A1=net394 S=net364
+ X=_0023_ VDD=VDD VSS=VSS
X_1095_ sg13cmos5l_mux2_1 $PINS A0=net394 A1=net386 S=net364 X=_0024_ VDD=VDD
+ VSS=VSS
X_1098_ sg13cmos5l_mux2_1 $PINS A0=net386 A1=\bias_gen_reg_din[4] S=net364
+ X=_0025_ VDD=VDD VSS=VSS
X_1101_ sg13cmos5l_mux2_1 $PINS A0=\bias_gen_reg_din[4] A1=\bias_gen_reg_din[5]
+ S=net364 X=_0026_ VDD=VDD VSS=VSS
X_1104_ sg13cmos5l_mux2_1 $PINS A0=\bias_gen_reg_din[5] A1=\bias_gen_reg_din[6]
+ S=net364 X=_0027_ VDD=VDD VSS=VSS
X_1107_ sg13cmos5l_mux2_1 $PINS A0=\bias_gen_reg_din[6] A1=net376 S=net364
+ X=_0028_ VDD=VDD VSS=VSS
X_1110_ sg13cmos5l_mux2_1 $PINS A0=\bias_gen_reg_din[7] A1=\bias_gen_reg_din[8]
+ S=net365 X=_0029_ VDD=VDD VSS=VSS
X_1111_ sg13cmos5l_mux2_1 $PINS A0=net374 A1=net372 S=net365 X=_0030_ VDD=VDD
+ VSS=VSS
X_1113_ sg13cmos5l_nor2_1 $PINS A=\bias_gen_reg_din[1] B=\bias_gen_reg_din[2]
+ Y=_0656_ VDD=VDD VSS=VSS
X_1114_ sg13cmos5l_or3_1 $PINS A=\bias_gen_reg_din[5] B=\bias_gen_reg_din[6]
+ C=\bias_gen_reg_din[7] X=_0657_ VDD=VDD VSS=VSS
X_1115_ sg13cmos5l_nor3_1 $PINS A=\bias_gen_reg_din[3] B=\bias_gen_reg_din[4]
+ C=_0657_ Y=_0658_ VDD=VDD VSS=VSS
X_1116_ sg13cmos5l_nand3_1 $PINS B=\u_spi_core.bit_cnt[2]
+ C=\u_spi_core.bit_cnt[3] A=\u_spi_core.bit_cnt[1] Y=_0659_ VDD=VDD VSS=VSS
X_1117_ sg13cmos5l_nor2_1 $PINS A=\u_spi_core.bit_cnt[4]
+ B=\u_spi_core.bit_cnt[5] Y=_0660_ VDD=VDD VSS=VSS
X_1118_ sg13cmos5l_and2_1 $PINS A=_0659_ B=_0660_ X=_0661_ VDD=VDD VSS=VSS
X_1121_ sg13cmos5l_nand3_1 $PINS B=_0658_ C=net351 A=_0656_ Y=_0664_ VDD=VDD
+ VSS=VSS
X_1122_ sg13cmos5l_or3_1 $PINS A=\u_spi_core.shift_in[22]
+ B=\u_spi_core.shift_in[23] C=\u_spi_core.shift_in[24] X=_0665_ VDD=VDD VSS=VSS
X_1123_ sg13cmos5l_nor3_1 $PINS A=\u_spi_core.shift_in[20]
+ B=\u_spi_core.shift_in[21] C=_0665_ Y=_0666_ VDD=VDD VSS=VSS
X_1126_ sg13cmos5l_nor2_1 $PINS A=net362 B=net360 Y=_0669_ VDD=VDD VSS=VSS
X_1127_ sg13cmos5l_nand2_2 $PINS Y=_0670_ A=_0659_ B=_0660_ VDD=VDD VSS=VSS
X_1129_ sg13cmos5l_nand3_1 $PINS B=_0669_ C=net344 A=_0666_ Y=_0672_ VDD=VDD
+ VSS=VSS
X_1130_ sg13cmos5l_nand2_1 $PINS Y=_0673_ A=_0664_ B=_0672_ VDD=VDD VSS=VSS
X_1132_ sg13cmos5l_and3_1 $PINS X=_0675_ A=\reg_out1[0] B=_0629_ C=_0673_
+ VDD=VDD VSS=VSS
X_1133_ sg13cmos5l_a21oi_1 $PINS VSS=VSS VDD=VDD A1=\bias_gen_reg_dout[0]
+ A2=net339 Y=_0676_ B1=_0675_
X_1134_ sg13cmos5l_or2_1 $PINS VSS=VSS VDD=VDD X=_0677_ B=_0673_ A=_0628_
X_1137_ sg13cmos5l_nor2b_1 $PINS A=net360 B_N=_0666_ Y=_0680_ VDD=VDD VSS=VSS
X_1138_ sg13cmos5l_inv_1 $PINS VDD=VDD Y=_0681_ A=_0658_ VSS=VSS
X_1139_ sg13cmos5l_nor3_1 $PINS A=net394 B=_0681_ C=net344 Y=_0682_ VDD=VDD
+ VSS=VSS
X_1140_ sg13cmos5l_a21oi_1 $PINS VSS=VSS VDD=VDD A1=net344 A2=_0680_ Y=_0683_
+ B1=_0682_
X_1142_ sg13cmos5l_nor2b_1 $PINS A=net363 B_N=\u_spi_core.shift_in[19] Y=_0685_
+ VDD=VDD VSS=VSS
X_1143_ sg13cmos5l_nand3_1 $PINS B=_0670_ C=_0685_ A=_0666_ Y=_0686_ VDD=VDD
+ VSS=VSS
X_1144_ sg13cmos5l_nor2b_1 $PINS A=\bias_gen_reg_din[1] B_N=net394 Y=_0687_
+ VDD=VDD VSS=VSS
X_1145_ sg13cmos5l_nand3_1 $PINS B=net351 C=_0687_ A=_0658_ Y=_0688_ VDD=VDD
+ VSS=VSS
X_1146_ sg13cmos5l_and2_1 $PINS A=_0686_ B=_0688_ X=_0689_ VDD=VDD VSS=VSS
X_1148_ sg13cmos5l_or2_1 $PINS VSS=VSS VDD=VDD X=_0691_ B=_0689_ A=\reg_out3[0]
X_1149_ sg13cmos5l_o21ai_1 $PINS B1=_0691_ VDD=VDD Y=_0692_ VSS=VSS
+ A1=\reg_out2[0] A2=net302
X_1150_ sg13cmos5l_or2_1 $PINS VSS=VSS VDD=VDD X=_0693_ B=_0692_ A=net303
X_1151_ sg13cmos5l_nor3_1 $PINS A=\bias_gen_reg_din[5] B=\bias_gen_reg_din[6]
+ C=\bias_gen_reg_din[7] Y=_0694_ VDD=VDD VSS=VSS
X_1152_ sg13cmos5l_nand4_1 $PINS B=net387 C=net383 A=net389 Y=_0695_ VDD=VDD
+ VSS=VSS D=_0694_
X_1153_ sg13cmos5l_nand2_1 $PINS Y=_0696_ A=\u_spi_core.shift_in[20]
+ B=\u_spi_core.shift_in[21] VDD=VDD VSS=VSS
X_1154_ sg13cmos5l_nor2_1 $PINS A=_0665_ B=_0696_ Y=_0697_ VDD=VDD VSS=VSS
X_1155_ sg13cmos5l_nand3_1 $PINS B=net349 C=_0697_ A=net358 Y=_0698_ VDD=VDD
+ VSS=VSS
X_1156_ sg13cmos5l_o21ai_1 $PINS B1=_0698_ VDD=VDD Y=_0699_ VSS=VSS A1=net349
+ A2=_0695_
X_1158_ sg13cmos5l_mux2_2 $PINS A0=\u_spi_core.shift_in[18] A1=net396 S=_0661_
+ X=_0701_ VDD=VDD VSS=VSS
X_1160_ sg13cmos5l_mux2_1 $PINS A0=\reg_out15[0] A1=\reg_out16[0] S=net335
+ X=_0703_ VDD=VDD VSS=VSS
X_1161_ sg13cmos5l_and2_1 $PINS A=net314 B=_0703_ X=_0704_ VDD=VDD VSS=VSS
X_1162_ sg13cmos5l_nand2b_1 $PINS Y=_0705_ B=net387 A_N=net389 VDD=VDD VSS=VSS
X_1163_ sg13cmos5l_nand3b_1 $PINS B=net389 C=net396 Y=_0706_ VDD=VDD VSS=VSS
+ A_N=net387
X_1164_ sg13cmos5l_o21ai_1 $PINS B1=_0706_ VDD=VDD Y=_0707_ VSS=VSS A1=net396
+ A2=_0705_
X_1165_ sg13cmos5l_nand4_1 $PINS B=_0694_ C=net352 A=net382 Y=_0708_ VDD=VDD
+ VSS=VSS D=_0707_
X_1166_ sg13cmos5l_nor3_1 $PINS A=\u_spi_core.shift_in[22]
+ B=\u_spi_core.shift_in[23] C=\u_spi_core.shift_in[24] Y=_0709_ VDD=VDD VSS=VSS
X_1167_ sg13cmos5l_nand2b_1 $PINS Y=_0710_ B=\u_spi_core.shift_in[20]
+ A_N=net358 VDD=VDD VSS=VSS
X_1168_ sg13cmos5l_nand3b_1 $PINS B=net358 C=net363 Y=_0711_ VDD=VDD VSS=VSS
+ A_N=\u_spi_core.shift_in[20]
X_1169_ sg13cmos5l_o21ai_1 $PINS B1=_0711_ VDD=VDD Y=_0712_ VSS=VSS A1=net363
+ A2=_0710_
X_1170_ sg13cmos5l_nand4_1 $PINS B=_0709_ C=net349 A=\u_spi_core.shift_in[21]
+ Y=_0713_ VDD=VDD VSS=VSS D=_0712_
X_1171_ sg13cmos5l_and2_1 $PINS A=_0708_ B=_0713_ X=_0714_ VDD=VDD VSS=VSS
X_1173_ sg13cmos5l_nand2b_1 $PINS Y=_0716_ B=net396 A_N=\bias_gen_reg_din[2]
+ VDD=VDD VSS=VSS
X_1174_ sg13cmos5l_nand2_1 $PINS Y=_0717_ A=\bias_gen_reg_din[3] B=net383
+ VDD=VDD VSS=VSS
X_1175_ sg13cmos5l_nor3_1 $PINS A=_0657_ B=_0716_ C=_0717_ Y=_0718_ VDD=VDD
+ VSS=VSS
X_1176_ sg13cmos5l_nand2b_1 $PINS Y=_0719_ B=\u_spi_core.shift_in[18]
+ A_N=net358 VDD=VDD VSS=VSS
X_1177_ sg13cmos5l_nor3_1 $PINS A=_0665_ B=_0719_ C=_0696_ Y=_0720_ VDD=VDD
+ VSS=VSS
X_1178_ sg13cmos5l_mux2_1 $PINS A0=_0718_ A1=_0720_ S=net349 X=_0721_ VDD=VDD
+ VSS=VSS
X_1180_ sg13cmos5l_nand2_1 $PINS Y=_0723_ A=\reg_out14[0] B=net333 VDD=VDD
+ VSS=VSS
X_1181_ sg13cmos5l_nand2_1 $PINS Y=_0724_ A=net313 B=_0723_ VDD=VDD VSS=VSS
X_1182_ sg13cmos5l_nand2_1 $PINS Y=_0725_ A=\reg_out12[0] B=net334 VDD=VDD
+ VSS=VSS
X_1183_ sg13cmos5l_nor2b_1 $PINS A=\u_spi_core.shift_in[20]
+ B_N=\u_spi_core.shift_in[21] Y=_0726_ VDD=VDD VSS=VSS
X_1184_ sg13cmos5l_nand2_1 $PINS Y=_0727_ A=_0709_ B=_0726_ VDD=VDD VSS=VSS
X_1185_ sg13cmos5l_nor2b_1 $PINS A=\bias_gen_reg_din[3] B_N=net383 Y=_0728_
+ VDD=VDD VSS=VSS
X_1186_ sg13cmos5l_nand4_1 $PINS B=_0694_ C=_0660_ A=_0659_ Y=_0729_ VDD=VDD
+ VSS=VSS D=_0728_
X_1187_ sg13cmos5l_o21ai_1 $PINS B1=_0729_ VDD=VDD Y=_0730_ VSS=VSS A1=_0661_
+ A2=_0727_
X_1188_ sg13cmos5l_mux2_1 $PINS A0=net358 A1=net389 S=net352 X=_0731_ VDD=VDD
+ VSS=VSS
X_1189_ sg13cmos5l_and2_1 $PINS A=_0730_ B=_0731_ X=_0732_ VDD=VDD VSS=VSS
X_1190_ sg13cmos5l_or2_1 $PINS VSS=VSS VDD=VDD X=_0733_
+ B=\u_spi_core.shift_in[19] A=\u_spi_core.shift_in[18]
X_1191_ sg13cmos5l_a21oi_1 $PINS VSS=VSS VDD=VDD A1=_0659_ A2=_0660_ Y=_0734_
+ B1=_0733_
X_1192_ sg13cmos5l_a21oi_1 $PINS VSS=VSS VDD=VDD A1=_0656_ A2=_0661_ Y=_0735_
+ B1=_0734_
X_1193_ sg13cmos5l_nand2_1 $PINS Y=_0736_ A=\u_spi_core.shift_in[18] B=net358
+ VDD=VDD VSS=VSS
X_1194_ sg13cmos5l_nor2b_1 $PINS A=_0736_ B_N=_0726_ Y=_0737_ VDD=VDD VSS=VSS
X_1195_ sg13cmos5l_nand2_1 $PINS Y=_0738_ A=net396 B=\bias_gen_reg_din[2]
+ VDD=VDD VSS=VSS
X_1196_ sg13cmos5l_nand2b_1 $PINS Y=_0739_ B=net383 A_N=\bias_gen_reg_din[3]
+ VDD=VDD VSS=VSS
X_1197_ sg13cmos5l_nor2_1 $PINS A=_0738_ B=_0739_ Y=_0740_ VDD=VDD VSS=VSS
X_1198_ sg13cmos5l_mux2_1 $PINS A0=_0737_ A1=_0740_ S=net352 X=_0741_ VDD=VDD
+ VSS=VSS
X_1199_ sg13cmos5l_or2_1 $PINS VSS=VSS VDD=VDD X=_0742_ B=_0717_ A=_0657_
X_1200_ sg13cmos5l_or2_1 $PINS VSS=VSS VDD=VDD X=_0743_ B=_0696_ A=_0665_
X_1201_ sg13cmos5l_mux2_1 $PINS A0=_0742_ A1=_0743_ S=net349 X=_0744_ VDD=VDD
+ VSS=VSS
X_1202_ sg13cmos5l_nor3_1 $PINS A=_0735_ B=_0741_ C=_0744_ Y=_0745_ VDD=VDD
+ VSS=VSS
X_1204_ sg13cmos5l_inv_1 $PINS VDD=VDD Y=_0747_ A=\reg_out13[0] VSS=VSS
X_1205_ sg13cmos5l_a22oi_1 $PINS Y=_0748_ B1=net311 B2=_0747_ A2=net312
+ A1=_0725_ VDD=VDD VSS=VSS
X_1206_ sg13cmos5l_o21ai_1 $PINS B1=_0748_ VDD=VDD Y=_0749_ VSS=VSS A1=_0704_
+ A2=_0724_
X_1210_ sg13cmos5l_inv_1 $PINS VDD=VDD Y=_0753_ A=\reg_out11[0] VSS=VSS
X_1213_ sg13cmos5l_o21ai_1 $PINS B1=net360 VDD=VDD Y=_0756_ VSS=VSS A1=_0753_
+ A2=net362
X_1214_ sg13cmos5l_o21ai_1 $PINS B1=_0756_ VDD=VDD Y=_0757_ VSS=VSS
+ A1=\reg_out9[0] A2=_0733_
X_1216_ sg13cmos5l_nor2_1 $PINS A=\reg_out9[0] B=net400 Y=_0759_ VDD=VDD
+ VSS=VSS
X_1219_ sg13cmos5l_nand3b_1 $PINS B=net388 C=\reg_out11[0] Y=_0762_ VDD=VDD
+ VSS=VSS A_N=net400
X_1220_ sg13cmos5l_o21ai_1 $PINS B1=_0762_ VDD=VDD Y=_0763_ VSS=VSS A1=net388
+ A2=_0759_
X_1221_ sg13cmos5l_nor2_1 $PINS A=net348 B=_0763_ Y=_0764_ VDD=VDD VSS=VSS
X_1222_ sg13cmos5l_a21oi_1 $PINS VSS=VSS VDD=VDD A1=net348 A2=_0757_ Y=_0765_
+ B1=_0764_
X_1223_ sg13cmos5l_nand2b_1 $PINS Y=_0766_ B=\u_spi_core.shift_in[20]
+ A_N=\u_spi_core.shift_in[21] VDD=VDD VSS=VSS
X_1224_ sg13cmos5l_nor2_1 $PINS A=_0665_ B=_0766_ Y=_0767_ VDD=VDD VSS=VSS
X_1225_ sg13cmos5l_nand2_1 $PINS Y=_0768_ A=net350 B=_0767_ VDD=VDD VSS=VSS
X_1226_ sg13cmos5l_nor2b_1 $PINS A=net383 B_N=\bias_gen_reg_din[3] Y=_0769_
+ VDD=VDD VSS=VSS
X_1227_ sg13cmos5l_nand3_1 $PINS B=net351 C=_0769_ A=_0694_ Y=_0770_ VDD=VDD
+ VSS=VSS
X_1228_ sg13cmos5l_nand2_1 $PINS Y=_0771_ A=_0768_ B=_0770_ VDD=VDD VSS=VSS
X_1230_ sg13cmos5l_a21oi_1 $PINS VSS=VSS VDD=VDD A1=net332 A2=_0765_ Y=_0773_
+ B1=net308
X_1231_ sg13cmos5l_nand4_1 $PINS B=net394 C=_0658_ A=\bias_gen_reg_din[1]
+ Y=_0774_ VDD=VDD VSS=VSS D=net351
X_1232_ sg13cmos5l_nand4_1 $PINS B=net360 C=_0666_ A=net362 Y=_0775_ VDD=VDD
+ VSS=VSS D=_0670_
X_1233_ sg13cmos5l_and2_1 $PINS A=_0774_ B=_0775_ X=_0776_ VDD=VDD VSS=VSS
X_1236_ sg13cmos5l_nor2_1 $PINS A=\reg_out9[0] B=net327 Y=_0779_ VDD=VDD
+ VSS=VSS
X_1237_ sg13cmos5l_mux2_1 $PINS A0=_0716_ A1=_0719_ S=_0670_ X=_0780_ VDD=VDD
+ VSS=VSS
X_1239_ sg13cmos5l_a21o_1 $PINS A2=net351 A1=_0656_ B1=_0734_ X=_0782_ VDD=VDD
+ VSS=VSS
X_1241_ sg13cmos5l_nor3_1 $PINS A=\reg_out10[0] B=net324 C=net321 Y=_0784_
+ VDD=VDD VSS=VSS
X_1243_ sg13cmos5l_o21ai_1 $PINS B1=net331 VDD=VDD Y=_0786_ VSS=VSS A1=_0779_
+ A2=_0784_
X_1244_ sg13cmos5l_and3_1 $PINS X=_0787_ A=_0659_ B=_0660_ C=_0687_ VDD=VDD
+ VSS=VSS
X_1245_ sg13cmos5l_a21oi_1 $PINS VSS=VSS VDD=VDD A1=net348 A2=_0685_ Y=_0788_
+ B1=_0787_
X_1247_ sg13cmos5l_nor2_1 $PINS A=\reg_out7[0] B=_0788_ Y=_0790_ VDD=VDD
+ VSS=VSS
X_1248_ sg13cmos5l_mux2_1 $PINS A0=_0736_ A1=_0738_ S=net351 X=_0791_ VDD=VDD
+ VSS=VSS
X_1250_ sg13cmos5l_a21o_1 $PINS A2=_0685_ A1=net348 B1=_0787_ X=_0793_ VDD=VDD
+ VSS=VSS
X_1252_ sg13cmos5l_nor3_1 $PINS A=\reg_out8[0] B=_0791_ C=_0793_ Y=_0795_
+ VDD=VDD VSS=VSS
X_1253_ sg13cmos5l_nand3_1 $PINS B=_0694_ C=_0769_ A=net389 Y=_0796_ VDD=VDD
+ VSS=VSS
X_1254_ sg13cmos5l_nand3_1 $PINS B=net350 C=_0767_ A=net358 Y=_0797_ VDD=VDD
+ VSS=VSS
X_1255_ sg13cmos5l_o21ai_1 $PINS B1=_0797_ VDD=VDD Y=_0798_ VSS=VSS A1=net350
+ A2=_0796_
X_1257_ sg13cmos5l_o21ai_1 $PINS B1=_0798_ VDD=VDD Y=_0800_ VSS=VSS A1=_0790_
+ A2=_0795_
X_1259_ sg13cmos5l_nor2_1 $PINS A=\reg_out5[0] B=net328 Y=_0802_ VDD=VDD
+ VSS=VSS
X_1262_ sg13cmos5l_nor3_1 $PINS A=\reg_out6[0] B=net326 C=net322 Y=_0805_
+ VDD=VDD VSS=VSS
X_1264_ sg13cmos5l_o21ai_1 $PINS B1=net309 VDD=VDD Y=_0807_ VSS=VSS A1=_0802_
+ A2=_0805_
X_1265_ sg13cmos5l_nand4_1 $PINS B=_0786_ C=_0800_ A=net307 Y=_0808_ VDD=VDD
+ VSS=VSS D=_0807_
X_1266_ sg13cmos5l_a21o_1 $PINS A2=_0773_ A1=_0749_ B1=_0808_ X=_0809_ VDD=VDD
+ VSS=VSS
X_1268_ sg13cmos5l_nand2b_1 $PINS Y=_0811_ B=_0658_ A_N=_0656_ VDD=VDD VSS=VSS
X_1269_ sg13cmos5l_nand3_1 $PINS B=_0733_ C=net344 A=_0666_ Y=_0812_ VDD=VDD
+ VSS=VSS
X_1270_ sg13cmos5l_o21ai_1 $PINS B1=_0812_ VDD=VDD Y=_0813_ VSS=VSS A1=net344
+ A2=_0811_
X_1272_ sg13cmos5l_nand3b_1 $PINS B=_0716_ C=net351 Y=_0815_ VDD=VDD VSS=VSS
+ A_N=_0687_
X_1273_ sg13cmos5l_o21ai_1 $PINS B1=_0815_ VDD=VDD Y=_0816_ VSS=VSS A1=net351
+ A2=_0736_
X_1275_ sg13cmos5l_nand2b_1 $PINS Y=_0818_ B=_0816_ A_N=\reg_out4[0] VDD=VDD
+ VSS=VSS
X_1276_ sg13cmos5l_a221oi_1 $PINS VDD=VDD VSS=VSS B2=_0818_ C1=_0675_ B1=_0813_
+ A1=\bias_gen_reg_dout[0] Y=_0819_ A2=net339
X_1277_ sg13cmos5l_a22oi_1 $PINS Y=_0031_ B1=_0809_ B2=_0819_ A2=_0693_
+ A1=_0676_ VDD=VDD VSS=VSS
X_1278_ sg13cmos5l_and3_1 $PINS X=_0820_ A=\reg_out1[10] B=net317 C=net316
+ VDD=VDD VSS=VSS
X_1279_ sg13cmos5l_a21oi_1 $PINS VSS=VSS VDD=VDD A1=\bias_gen_reg_dout[10]
+ A2=net337 Y=_0821_ B1=_0820_
X_1280_ sg13cmos5l_or2_1 $PINS VSS=VSS VDD=VDD X=_0822_ B=net315
+ A=\reg_out3[10]
X_1281_ sg13cmos5l_o21ai_1 $PINS B1=_0822_ VDD=VDD Y=_0823_ VSS=VSS
+ A1=\reg_out2[10] A2=_0683_
X_1282_ sg13cmos5l_or2_1 $PINS VSS=VSS VDD=VDD X=_0824_ B=_0823_ A=net303
X_1283_ sg13cmos5l_mux2_1 $PINS A0=\reg_out15[10] A1=\reg_out16[10] S=net336
+ X=_0825_ VDD=VDD VSS=VSS
X_1284_ sg13cmos5l_and2_1 $PINS A=_0699_ B=_0825_ X=_0826_ VDD=VDD VSS=VSS
X_1285_ sg13cmos5l_nand2_1 $PINS Y=_0827_ A=\reg_out14[10] B=net333 VDD=VDD
+ VSS=VSS
X_1286_ sg13cmos5l_nand2_1 $PINS Y=_0828_ A=_0714_ B=_0827_ VDD=VDD VSS=VSS
X_1287_ sg13cmos5l_inv_1 $PINS VDD=VDD Y=_0829_ A=\reg_out13[10] VSS=VSS
X_1289_ sg13cmos5l_nand2_1 $PINS Y=_0831_ A=\reg_out12[10] B=_0701_ VDD=VDD
+ VSS=VSS
X_1291_ sg13cmos5l_a22oi_1 $PINS Y=_0833_ B1=_0831_ B2=_0732_ A2=_0745_
+ A1=_0829_ VDD=VDD VSS=VSS
X_1292_ sg13cmos5l_o21ai_1 $PINS B1=_0833_ VDD=VDD Y=_0834_ VSS=VSS A1=_0826_
+ A2=_0828_
X_1293_ sg13cmos5l_inv_1 $PINS VDD=VDD Y=_0835_ A=\reg_out11[10] VSS=VSS
X_1294_ sg13cmos5l_o21ai_1 $PINS B1=net359 VDD=VDD Y=_0836_ VSS=VSS A1=_0835_
+ A2=net361
X_1295_ sg13cmos5l_o21ai_1 $PINS B1=_0836_ VDD=VDD Y=_0837_ VSS=VSS
+ A1=\reg_out9[10] A2=net357
X_1298_ sg13cmos5l_nor2_1 $PINS A=\reg_out9[10] B=net398 Y=_0840_ VDD=VDD
+ VSS=VSS
X_1299_ sg13cmos5l_nand3b_1 $PINS B=net393 C=\reg_out11[10] Y=_0841_ VDD=VDD
+ VSS=VSS A_N=net398
X_1300_ sg13cmos5l_o21ai_1 $PINS B1=_0841_ VDD=VDD Y=_0842_ VSS=VSS A1=net392
+ A2=_0840_
X_1301_ sg13cmos5l_nor2_1 $PINS A=net346 B=_0842_ Y=_0843_ VDD=VDD VSS=VSS
X_1302_ sg13cmos5l_a21oi_1 $PINS VSS=VSS VDD=VDD A1=net346 A2=_0837_ Y=_0844_
+ B1=_0843_
X_1303_ sg13cmos5l_a21oi_1 $PINS VSS=VSS VDD=VDD A1=net330 A2=_0844_ Y=_0845_
+ B1=net308
X_1304_ sg13cmos5l_nor2_1 $PINS A=\reg_out9[10] B=net327 Y=_0846_ VDD=VDD
+ VSS=VSS
X_1305_ sg13cmos5l_nor3_1 $PINS A=\reg_out10[10] B=net324 C=_0782_ Y=_0847_
+ VDD=VDD VSS=VSS
X_1306_ sg13cmos5l_o21ai_1 $PINS B1=net332 VDD=VDD Y=_0848_ VSS=VSS A1=_0846_
+ A2=_0847_
X_1307_ sg13cmos5l_nor2_1 $PINS A=\reg_out7[10] B=_0788_ Y=_0849_ VDD=VDD
+ VSS=VSS
X_1308_ sg13cmos5l_nor3_1 $PINS A=\reg_out8[10] B=net319 C=net318 Y=_0850_
+ VDD=VDD VSS=VSS
X_1309_ sg13cmos5l_o21ai_1 $PINS B1=net306 VDD=VDD Y=_0851_ VSS=VSS A1=_0849_
+ A2=_0850_
X_1310_ sg13cmos5l_nor2_1 $PINS A=\reg_out5[10] B=net329 Y=_0852_ VDD=VDD
+ VSS=VSS
X_1311_ sg13cmos5l_nor3_1 $PINS A=\reg_out6[10] B=_0780_ C=net323 Y=_0853_
+ VDD=VDD VSS=VSS
X_1312_ sg13cmos5l_o21ai_1 $PINS B1=net310 VDD=VDD Y=_0854_ VSS=VSS A1=_0852_
+ A2=_0853_
X_1313_ sg13cmos5l_nand4_1 $PINS B=_0848_ C=_0851_ A=_0776_ Y=_0855_ VDD=VDD
+ VSS=VSS D=_0854_
X_1314_ sg13cmos5l_a21o_1 $PINS A2=_0845_ A1=_0834_ B1=_0855_ X=_0856_ VDD=VDD
+ VSS=VSS
X_1315_ sg13cmos5l_nand2b_1 $PINS Y=_0857_ B=net304 A_N=\reg_out4[10] VDD=VDD
+ VSS=VSS
X_1316_ sg13cmos5l_a221oi_1 $PINS VDD=VDD VSS=VSS B2=_0857_ C1=_0820_ B1=net305
+ A1=\bias_gen_reg_dout[10] Y=_0858_ A2=net337
X_1317_ sg13cmos5l_a22oi_1 $PINS Y=_0032_ B1=_0856_ B2=_0858_ A2=_0824_
+ A1=_0821_ VDD=VDD VSS=VSS
X_1318_ sg13cmos5l_and3_1 $PINS X=_0859_ A=\reg_out1[1] B=_0629_ C=_0673_
+ VDD=VDD VSS=VSS
X_1319_ sg13cmos5l_a21oi_1 $PINS VSS=VSS VDD=VDD A1=\bias_gen_reg_dout[1]
+ A2=net339 Y=_0860_ B1=_0859_
X_1320_ sg13cmos5l_or2_1 $PINS VSS=VSS VDD=VDD X=_0861_ B=net315 A=\reg_out3[1]
X_1321_ sg13cmos5l_o21ai_1 $PINS B1=_0861_ VDD=VDD Y=_0862_ VSS=VSS
+ A1=\reg_out2[1] A2=net302
X_1322_ sg13cmos5l_or2_1 $PINS VSS=VSS VDD=VDD X=_0863_ B=_0862_ A=net303
X_1323_ sg13cmos5l_mux2_1 $PINS A0=\reg_out15[1] A1=\reg_out16[1] S=net335
+ X=_0864_ VDD=VDD VSS=VSS
X_1324_ sg13cmos5l_and2_1 $PINS A=net314 B=_0864_ X=_0865_ VDD=VDD VSS=VSS
X_1325_ sg13cmos5l_nand2_1 $PINS Y=_0866_ A=\reg_out14[1] B=net333 VDD=VDD
+ VSS=VSS
X_1326_ sg13cmos5l_nand2_1 $PINS Y=_0867_ A=net313 B=_0866_ VDD=VDD VSS=VSS
X_1327_ sg13cmos5l_inv_1 $PINS VDD=VDD Y=_0868_ A=\reg_out13[1] VSS=VSS
X_1328_ sg13cmos5l_nand2_1 $PINS Y=_0869_ A=\reg_out12[1] B=net334 VDD=VDD
+ VSS=VSS
X_1329_ sg13cmos5l_a22oi_1 $PINS Y=_0870_ B1=_0869_ B2=net312 A2=net311
+ A1=_0868_ VDD=VDD VSS=VSS
X_1330_ sg13cmos5l_o21ai_1 $PINS B1=_0870_ VDD=VDD Y=_0871_ VSS=VSS A1=_0865_
+ A2=_0867_
X_1331_ sg13cmos5l_inv_1 $PINS VDD=VDD Y=_0872_ A=\reg_out11[1] VSS=VSS
X_1332_ sg13cmos5l_o21ai_1 $PINS B1=net360 VDD=VDD Y=_0873_ VSS=VSS A1=_0872_
+ A2=net362
X_1333_ sg13cmos5l_o21ai_1 $PINS B1=_0873_ VDD=VDD Y=_0874_ VSS=VSS
+ A1=\reg_out9[1] A2=_0733_
X_1334_ sg13cmos5l_nor2_1 $PINS A=\reg_out9[1] B=net400 Y=_0875_ VDD=VDD
+ VSS=VSS
X_1335_ sg13cmos5l_nand3b_1 $PINS B=net390 C=\reg_out11[1] Y=_0876_ VDD=VDD
+ VSS=VSS A_N=net395
X_1336_ sg13cmos5l_o21ai_1 $PINS B1=_0876_ VDD=VDD Y=_0877_ VSS=VSS A1=net388
+ A2=_0875_
X_1337_ sg13cmos5l_nor2_1 $PINS A=net348 B=_0877_ Y=_0878_ VDD=VDD VSS=VSS
X_1338_ sg13cmos5l_a21oi_1 $PINS VSS=VSS VDD=VDD A1=net345 A2=_0874_ Y=_0879_
+ B1=_0878_
X_1339_ sg13cmos5l_a21oi_1 $PINS VSS=VSS VDD=VDD A1=_0730_ A2=_0879_ Y=_0880_
+ B1=_0771_
X_1340_ sg13cmos5l_nor2_1 $PINS A=\reg_out9[1] B=net327 Y=_0881_ VDD=VDD
+ VSS=VSS
X_1341_ sg13cmos5l_nor3_1 $PINS A=\reg_out10[1] B=net324 C=net321 Y=_0882_
+ VDD=VDD VSS=VSS
X_1342_ sg13cmos5l_o21ai_1 $PINS B1=net331 VDD=VDD Y=_0883_ VSS=VSS A1=_0881_
+ A2=_0882_
X_1343_ sg13cmos5l_nor2_1 $PINS A=\reg_out7[1] B=_0788_ Y=_0884_ VDD=VDD
+ VSS=VSS
X_1344_ sg13cmos5l_nor3_1 $PINS A=\reg_out8[1] B=_0791_ C=_0793_ Y=_0885_
+ VDD=VDD VSS=VSS
X_1345_ sg13cmos5l_o21ai_1 $PINS B1=_0798_ VDD=VDD Y=_0886_ VSS=VSS A1=_0884_
+ A2=_0885_
X_1346_ sg13cmos5l_nor2_1 $PINS A=\reg_out5[1] B=net329 Y=_0887_ VDD=VDD
+ VSS=VSS
X_1347_ sg13cmos5l_nor3_1 $PINS A=\reg_out6[1] B=_0780_ C=net323 Y=_0888_
+ VDD=VDD VSS=VSS
X_1348_ sg13cmos5l_o21ai_1 $PINS B1=net309 VDD=VDD Y=_0889_ VSS=VSS A1=_0887_
+ A2=_0888_
X_1349_ sg13cmos5l_nand4_1 $PINS B=_0883_ C=_0886_ A=net307 Y=_0890_ VDD=VDD
+ VSS=VSS D=_0889_
X_1350_ sg13cmos5l_a21o_1 $PINS A2=_0880_ A1=_0871_ B1=_0890_ X=_0891_ VDD=VDD
+ VSS=VSS
X_1351_ sg13cmos5l_nand2b_1 $PINS Y=_0892_ B=_0816_ A_N=\reg_out4[1] VDD=VDD
+ VSS=VSS
X_1352_ sg13cmos5l_a221oi_1 $PINS VDD=VDD VSS=VSS B2=_0892_ C1=_0859_ B1=_0813_
+ A1=\bias_gen_reg_dout[1] Y=_0893_ A2=net339
X_1353_ sg13cmos5l_a22oi_1 $PINS Y=_0033_ B1=_0891_ B2=_0893_ A2=_0863_
+ A1=_0860_ VDD=VDD VSS=VSS
X_1354_ sg13cmos5l_and3_1 $PINS X=_0894_ A=\reg_out1[2] B=_0629_ C=_0673_
+ VDD=VDD VSS=VSS
X_1355_ sg13cmos5l_a21oi_1 $PINS VSS=VSS VDD=VDD A1=\bias_gen_reg_dout[2]
+ A2=net339 Y=_0895_ B1=_0894_
X_1356_ sg13cmos5l_or2_1 $PINS VSS=VSS VDD=VDD X=_0896_ B=net315 A=\reg_out3[2]
X_1357_ sg13cmos5l_o21ai_1 $PINS B1=_0896_ VDD=VDD Y=_0897_ VSS=VSS
+ A1=\reg_out2[2] A2=net302
X_1358_ sg13cmos5l_or2_1 $PINS VSS=VSS VDD=VDD X=_0898_ B=_0897_ A=net303
X_1359_ sg13cmos5l_mux2_1 $PINS A0=\reg_out15[2] A1=\reg_out16[2] S=net336
+ X=_0899_ VDD=VDD VSS=VSS
X_1360_ sg13cmos5l_and2_1 $PINS A=net314 B=_0899_ X=_0900_ VDD=VDD VSS=VSS
X_1361_ sg13cmos5l_nand2_1 $PINS Y=_0901_ A=\reg_out14[2] B=net333 VDD=VDD
+ VSS=VSS
X_1362_ sg13cmos5l_nand2_1 $PINS Y=_0902_ A=_0714_ B=_0901_ VDD=VDD VSS=VSS
X_1363_ sg13cmos5l_inv_1 $PINS VDD=VDD Y=_0903_ A=\reg_out13[2] VSS=VSS
X_1364_ sg13cmos5l_nand2_1 $PINS Y=_0904_ A=\reg_out12[2] B=net334 VDD=VDD
+ VSS=VSS
X_1365_ sg13cmos5l_a22oi_1 $PINS Y=_0905_ B1=_0904_ B2=net312 A2=net311
+ A1=_0903_ VDD=VDD VSS=VSS
X_1366_ sg13cmos5l_o21ai_1 $PINS B1=_0905_ VDD=VDD Y=_0906_ VSS=VSS A1=_0900_
+ A2=_0902_
X_1367_ sg13cmos5l_inv_1 $PINS VDD=VDD Y=_0907_ A=\reg_out11[2] VSS=VSS
X_1368_ sg13cmos5l_o21ai_1 $PINS B1=net359 VDD=VDD Y=_0908_ VSS=VSS A1=_0907_
+ A2=net361
X_1369_ sg13cmos5l_o21ai_1 $PINS B1=_0908_ VDD=VDD Y=_0909_ VSS=VSS
+ A1=\reg_out9[2] A2=_0733_
X_1370_ sg13cmos5l_nor2_1 $PINS A=\reg_out9[2] B=net400 Y=_0910_ VDD=VDD
+ VSS=VSS
X_1371_ sg13cmos5l_nand3b_1 $PINS B=net388 C=\reg_out11[2] Y=_0911_ VDD=VDD
+ VSS=VSS A_N=net400
X_1372_ sg13cmos5l_o21ai_1 $PINS B1=_0911_ VDD=VDD Y=_0912_ VSS=VSS A1=net388
+ A2=_0910_
X_1373_ sg13cmos5l_nor2_1 $PINS A=net345 B=_0912_ Y=_0913_ VDD=VDD VSS=VSS
X_1374_ sg13cmos5l_a21oi_1 $PINS VSS=VSS VDD=VDD A1=net345 A2=_0909_ Y=_0914_
+ B1=_0913_
X_1375_ sg13cmos5l_a21oi_1 $PINS VSS=VSS VDD=VDD A1=_0730_ A2=_0914_ Y=_0915_
+ B1=_0771_
X_1376_ sg13cmos5l_nor2_1 $PINS A=\reg_out9[2] B=net327 Y=_0916_ VDD=VDD
+ VSS=VSS
X_1377_ sg13cmos5l_nor3_1 $PINS A=\reg_out10[2] B=net324 C=_0782_ Y=_0917_
+ VDD=VDD VSS=VSS
X_1378_ sg13cmos5l_o21ai_1 $PINS B1=net332 VDD=VDD Y=_0918_ VSS=VSS A1=_0916_
+ A2=_0917_
X_1379_ sg13cmos5l_nor2_1 $PINS A=\reg_out7[2] B=_0788_ Y=_0919_ VDD=VDD
+ VSS=VSS
X_1380_ sg13cmos5l_nor3_1 $PINS A=\reg_out8[2] B=_0791_ C=_0793_ Y=_0920_
+ VDD=VDD VSS=VSS
X_1381_ sg13cmos5l_o21ai_1 $PINS B1=_0798_ VDD=VDD Y=_0921_ VSS=VSS A1=_0919_
+ A2=_0920_
X_1382_ sg13cmos5l_nor2_1 $PINS A=\reg_out5[2] B=net328 Y=_0922_ VDD=VDD
+ VSS=VSS
X_1383_ sg13cmos5l_nor3_1 $PINS A=\reg_out6[2] B=net326 C=net322 Y=_0923_
+ VDD=VDD VSS=VSS
X_1384_ sg13cmos5l_o21ai_1 $PINS B1=net309 VDD=VDD Y=_0924_ VSS=VSS A1=_0922_
+ A2=_0923_
X_1385_ sg13cmos5l_nand4_1 $PINS B=_0918_ C=_0921_ A=net307 Y=_0925_ VDD=VDD
+ VSS=VSS D=_0924_
X_1386_ sg13cmos5l_a21o_1 $PINS A2=_0915_ A1=_0906_ B1=_0925_ X=_0926_ VDD=VDD
+ VSS=VSS
X_1387_ sg13cmos5l_nand2b_1 $PINS Y=_0927_ B=_0816_ A_N=\reg_out4[2] VDD=VDD
+ VSS=VSS
X_1388_ sg13cmos5l_a221oi_1 $PINS VDD=VDD VSS=VSS B2=_0927_ C1=_0894_ B1=_0813_
+ A1=\bias_gen_reg_dout[2] Y=_0928_ A2=net339
X_1389_ sg13cmos5l_a22oi_1 $PINS Y=_0034_ B1=_0926_ B2=_0928_ A2=_0898_
+ A1=_0895_ VDD=VDD VSS=VSS
X_1390_ sg13cmos5l_and3_1 $PINS X=_0929_ A=\reg_out1[3] B=net317 C=net316
+ VDD=VDD VSS=VSS
X_1391_ sg13cmos5l_a21oi_1 $PINS VSS=VSS VDD=VDD A1=\bias_gen_reg_dout[3]
+ A2=net337 Y=_0930_ B1=_0929_
X_1392_ sg13cmos5l_or2_1 $PINS VSS=VSS VDD=VDD X=_0931_ B=net315 A=\reg_out3[3]
X_1393_ sg13cmos5l_o21ai_1 $PINS B1=_0931_ VDD=VDD Y=_0932_ VSS=VSS
+ A1=\reg_out2[3] A2=_0683_
X_1394_ sg13cmos5l_or2_1 $PINS VSS=VSS VDD=VDD X=_0933_ B=_0932_ A=_0677_
X_1395_ sg13cmos5l_mux2_1 $PINS A0=\reg_out15[3] A1=\reg_out16[3] S=net336
+ X=_0934_ VDD=VDD VSS=VSS
X_1396_ sg13cmos5l_and2_1 $PINS A=_0699_ B=_0934_ X=_0935_ VDD=VDD VSS=VSS
X_1397_ sg13cmos5l_nand2_1 $PINS Y=_0936_ A=\reg_out14[3] B=net333 VDD=VDD
+ VSS=VSS
X_1398_ sg13cmos5l_nand2_1 $PINS Y=_0937_ A=_0714_ B=_0936_ VDD=VDD VSS=VSS
X_1399_ sg13cmos5l_inv_1 $PINS VDD=VDD Y=_0938_ A=\reg_out13[3] VSS=VSS
X_1400_ sg13cmos5l_nand2_1 $PINS Y=_0939_ A=\reg_out12[3] B=net336 VDD=VDD
+ VSS=VSS
X_1401_ sg13cmos5l_a22oi_1 $PINS Y=_0940_ B1=_0939_ B2=_0732_ A2=_0745_
+ A1=_0938_ VDD=VDD VSS=VSS
X_1402_ sg13cmos5l_o21ai_1 $PINS B1=_0940_ VDD=VDD Y=_0941_ VSS=VSS A1=_0935_
+ A2=_0937_
X_1403_ sg13cmos5l_inv_1 $PINS VDD=VDD Y=_0942_ A=\reg_out11[3] VSS=VSS
X_1404_ sg13cmos5l_o21ai_1 $PINS B1=net359 VDD=VDD Y=_0943_ VSS=VSS A1=_0942_
+ A2=net361
X_1405_ sg13cmos5l_o21ai_1 $PINS B1=_0943_ VDD=VDD Y=_0944_ VSS=VSS
+ A1=\reg_out9[3] A2=net357
X_1406_ sg13cmos5l_nor2_1 $PINS A=\reg_out9[3] B=net398 Y=_0945_ VDD=VDD
+ VSS=VSS
X_1407_ sg13cmos5l_nand3b_1 $PINS B=net393 C=\reg_out11[3] Y=_0946_ VDD=VDD
+ VSS=VSS A_N=net399
X_1408_ sg13cmos5l_o21ai_1 $PINS B1=_0946_ VDD=VDD Y=_0947_ VSS=VSS A1=net392
+ A2=_0945_
X_1409_ sg13cmos5l_nor2_1 $PINS A=net346 B=_0947_ Y=_0948_ VDD=VDD VSS=VSS
X_1410_ sg13cmos5l_a21oi_1 $PINS VSS=VSS VDD=VDD A1=net347 A2=_0944_ Y=_0949_
+ B1=_0948_
X_1411_ sg13cmos5l_a21oi_1 $PINS VSS=VSS VDD=VDD A1=net330 A2=_0949_ Y=_0950_
+ B1=net308
X_1412_ sg13cmos5l_nor2_1 $PINS A=\reg_out9[3] B=_0735_ Y=_0951_ VDD=VDD
+ VSS=VSS
X_1413_ sg13cmos5l_nor3_1 $PINS A=\reg_out10[3] B=net325 C=net323 Y=_0952_
+ VDD=VDD VSS=VSS
X_1414_ sg13cmos5l_o21ai_1 $PINS B1=net332 VDD=VDD Y=_0953_ VSS=VSS A1=_0951_
+ A2=_0952_
X_1415_ sg13cmos5l_nor2_1 $PINS A=\reg_out7[3] B=net320 Y=_0954_ VDD=VDD
+ VSS=VSS
X_1416_ sg13cmos5l_nor3_1 $PINS A=\reg_out8[3] B=net319 C=net318 Y=_0955_
+ VDD=VDD VSS=VSS
X_1417_ sg13cmos5l_o21ai_1 $PINS B1=net306 VDD=VDD Y=_0956_ VSS=VSS A1=_0954_
+ A2=_0955_
X_1418_ sg13cmos5l_nor2_1 $PINS A=\reg_out5[3] B=_0735_ Y=_0957_ VDD=VDD
+ VSS=VSS
X_1419_ sg13cmos5l_nor3_1 $PINS A=\reg_out6[3] B=net325 C=net323 Y=_0958_
+ VDD=VDD VSS=VSS
X_1420_ sg13cmos5l_o21ai_1 $PINS B1=net310 VDD=VDD Y=_0959_ VSS=VSS A1=_0957_
+ A2=_0958_
X_1421_ sg13cmos5l_nand4_1 $PINS B=_0953_ C=_0956_ A=_0776_ Y=_0960_ VDD=VDD
+ VSS=VSS D=_0959_
X_1422_ sg13cmos5l_a21o_1 $PINS A2=_0950_ A1=_0941_ B1=_0960_ X=_0961_ VDD=VDD
+ VSS=VSS
X_1423_ sg13cmos5l_nand2b_1 $PINS Y=_0962_ B=net304 A_N=\reg_out4[3] VDD=VDD
+ VSS=VSS
X_1424_ sg13cmos5l_a221oi_1 $PINS VDD=VDD VSS=VSS B2=_0962_ C1=_0929_ B1=net305
+ A1=\bias_gen_reg_dout[3] Y=_0963_ A2=net337
X_1425_ sg13cmos5l_a22oi_1 $PINS Y=_0035_ B1=_0961_ B2=_0963_ A2=_0933_
+ A1=_0930_ VDD=VDD VSS=VSS
X_1426_ sg13cmos5l_and3_1 $PINS X=_0964_ A=\reg_out1[4] B=net317 C=net316
+ VDD=VDD VSS=VSS
X_1427_ sg13cmos5l_a21oi_1 $PINS VSS=VSS VDD=VDD A1=\bias_gen_reg_dout[4]
+ A2=net337 Y=_0965_ B1=_0964_
X_1428_ sg13cmos5l_or2_1 $PINS VSS=VSS VDD=VDD X=_0966_ B=net315 A=\reg_out3[4]
X_1429_ sg13cmos5l_o21ai_1 $PINS B1=_0966_ VDD=VDD Y=_0967_ VSS=VSS
+ A1=\reg_out2[4] A2=_0683_
X_1430_ sg13cmos5l_or2_1 $PINS VSS=VSS VDD=VDD X=_0968_ B=_0967_ A=net303
X_1431_ sg13cmos5l_mux2_1 $PINS A0=\reg_out15[4] A1=\reg_out16[4] S=net336
+ X=_0969_ VDD=VDD VSS=VSS
X_1432_ sg13cmos5l_and2_1 $PINS A=_0699_ B=_0969_ X=_0970_ VDD=VDD VSS=VSS
X_1433_ sg13cmos5l_nand2_1 $PINS Y=_0971_ A=\reg_out14[4] B=net333 VDD=VDD
+ VSS=VSS
X_1434_ sg13cmos5l_nand2_1 $PINS Y=_0972_ A=_0714_ B=_0971_ VDD=VDD VSS=VSS
X_1435_ sg13cmos5l_inv_1 $PINS VDD=VDD Y=_0973_ A=\reg_out13[4] VSS=VSS
X_1436_ sg13cmos5l_nand2_1 $PINS Y=_0974_ A=\reg_out12[4] B=_0701_ VDD=VDD
+ VSS=VSS
X_1437_ sg13cmos5l_a22oi_1 $PINS Y=_0975_ B1=_0974_ B2=_0732_ A2=_0745_
+ A1=_0973_ VDD=VDD VSS=VSS
X_1438_ sg13cmos5l_o21ai_1 $PINS B1=_0975_ VDD=VDD Y=_0273_ VSS=VSS A1=_0970_
+ A2=_0972_
X_1439_ sg13cmos5l_inv_1 $PINS VDD=VDD Y=_0274_ A=\reg_out11[4] VSS=VSS
X_1440_ sg13cmos5l_o21ai_1 $PINS B1=net359 VDD=VDD Y=_0275_ VSS=VSS A1=_0274_
+ A2=net361
X_1441_ sg13cmos5l_o21ai_1 $PINS B1=_0275_ VDD=VDD Y=_0276_ VSS=VSS
+ A1=\reg_out9[4] A2=net357
X_1442_ sg13cmos5l_nor2_1 $PINS A=\reg_out9[4] B=net398 Y=_0277_ VDD=VDD
+ VSS=VSS
X_1443_ sg13cmos5l_nand3b_1 $PINS B=net393 C=\reg_out11[4] Y=_0278_ VDD=VDD
+ VSS=VSS A_N=net399
X_1444_ sg13cmos5l_o21ai_1 $PINS B1=_0278_ VDD=VDD Y=_0279_ VSS=VSS A1=net392
+ A2=_0277_
X_1445_ sg13cmos5l_nor2_1 $PINS A=net346 B=_0279_ Y=_0280_ VDD=VDD VSS=VSS
X_1446_ sg13cmos5l_a21oi_1 $PINS VSS=VSS VDD=VDD A1=net346 A2=_0276_ Y=_0281_
+ B1=_0280_
X_1447_ sg13cmos5l_a21oi_1 $PINS VSS=VSS VDD=VDD A1=net330 A2=_0281_ Y=_0282_
+ B1=net308
X_1448_ sg13cmos5l_nor2_1 $PINS A=\reg_out9[4] B=_0735_ Y=_0283_ VDD=VDD
+ VSS=VSS
X_1449_ sg13cmos5l_nor3_1 $PINS A=\reg_out10[4] B=net325 C=_0782_ Y=_0284_
+ VDD=VDD VSS=VSS
X_1450_ sg13cmos5l_o21ai_1 $PINS B1=net332 VDD=VDD Y=_0285_ VSS=VSS A1=_0283_
+ A2=_0284_
X_1451_ sg13cmos5l_nor2_1 $PINS A=\reg_out7[4] B=net320 Y=_0286_ VDD=VDD
+ VSS=VSS
X_1452_ sg13cmos5l_nor3_1 $PINS A=\reg_out8[4] B=net319 C=net318 Y=_0287_
+ VDD=VDD VSS=VSS
X_1453_ sg13cmos5l_o21ai_1 $PINS B1=net306 VDD=VDD Y=_0288_ VSS=VSS A1=_0286_
+ A2=_0287_
X_1454_ sg13cmos5l_nor2_1 $PINS A=\reg_out5[4] B=net329 Y=_0289_ VDD=VDD
+ VSS=VSS
X_1455_ sg13cmos5l_nor3_1 $PINS A=\reg_out6[4] B=net325 C=net323 Y=_0290_
+ VDD=VDD VSS=VSS
X_1456_ sg13cmos5l_o21ai_1 $PINS B1=net310 VDD=VDD Y=_0291_ VSS=VSS A1=_0289_
+ A2=_0290_
X_1457_ sg13cmos5l_nand4_1 $PINS B=_0285_ C=_0288_ A=_0776_ Y=_0292_ VDD=VDD
+ VSS=VSS D=_0291_
X_1458_ sg13cmos5l_a21o_1 $PINS A2=_0282_ A1=_0273_ B1=_0292_ X=_0293_ VDD=VDD
+ VSS=VSS
X_1459_ sg13cmos5l_nand2b_1 $PINS Y=_0294_ B=net304 A_N=\reg_out4[4] VDD=VDD
+ VSS=VSS
X_1460_ sg13cmos5l_a221oi_1 $PINS VDD=VDD VSS=VSS B2=_0294_ C1=_0964_ B1=net305
+ A1=\bias_gen_reg_dout[4] Y=_0295_ A2=net337
X_1461_ sg13cmos5l_a22oi_1 $PINS Y=_0036_ B1=_0293_ B2=_0295_ A2=_0968_
+ A1=_0965_ VDD=VDD VSS=VSS
X_1462_ sg13cmos5l_and3_1 $PINS X=_0296_ A=\reg_out1[5] B=net317 C=net316
+ VDD=VDD VSS=VSS
X_1463_ sg13cmos5l_a21oi_1 $PINS VSS=VSS VDD=VDD A1=\bias_gen_reg_dout[5]
+ A2=net337 Y=_0297_ B1=_0296_
X_1464_ sg13cmos5l_or2_1 $PINS VSS=VSS VDD=VDD X=_0298_ B=_0689_ A=\reg_out3[5]
X_1465_ sg13cmos5l_o21ai_1 $PINS B1=_0298_ VDD=VDD Y=_0299_ VSS=VSS
+ A1=\reg_out2[5] A2=net302
X_1466_ sg13cmos5l_or2_1 $PINS VSS=VSS VDD=VDD X=_0300_ B=_0299_ A=net303
X_1467_ sg13cmos5l_mux2_1 $PINS A0=\reg_out15[5] A1=\reg_out16[5] S=net336
+ X=_0301_ VDD=VDD VSS=VSS
X_1468_ sg13cmos5l_and2_1 $PINS A=net314 B=_0301_ X=_0302_ VDD=VDD VSS=VSS
X_1469_ sg13cmos5l_nand2_1 $PINS Y=_0303_ A=\reg_out14[5] B=net333 VDD=VDD
+ VSS=VSS
X_1470_ sg13cmos5l_nand2_1 $PINS Y=_0304_ A=_0714_ B=_0303_ VDD=VDD VSS=VSS
X_1471_ sg13cmos5l_inv_1 $PINS VDD=VDD Y=_0305_ A=\reg_out13[5] VSS=VSS
X_1472_ sg13cmos5l_nand2_1 $PINS Y=_0306_ A=\reg_out12[5] B=net334 VDD=VDD
+ VSS=VSS
X_1473_ sg13cmos5l_a22oi_1 $PINS Y=_0307_ B1=_0306_ B2=net312 A2=net311
+ A1=_0305_ VDD=VDD VSS=VSS
X_1474_ sg13cmos5l_o21ai_1 $PINS B1=_0307_ VDD=VDD Y=_0308_ VSS=VSS A1=_0302_
+ A2=_0304_
X_1475_ sg13cmos5l_inv_1 $PINS VDD=VDD Y=_0309_ A=\reg_out11[5] VSS=VSS
X_1476_ sg13cmos5l_o21ai_1 $PINS B1=net359 VDD=VDD Y=_0310_ VSS=VSS A1=_0309_
+ A2=net361
X_1477_ sg13cmos5l_o21ai_1 $PINS B1=_0310_ VDD=VDD Y=_0311_ VSS=VSS
+ A1=\reg_out9[5] A2=net357
X_1478_ sg13cmos5l_nor2_1 $PINS A=\reg_out9[5] B=net399 Y=_0312_ VDD=VDD
+ VSS=VSS
X_1479_ sg13cmos5l_nand3b_1 $PINS B=net388 C=\reg_out11[5] Y=_0313_ VDD=VDD
+ VSS=VSS A_N=net400
X_1480_ sg13cmos5l_o21ai_1 $PINS B1=_0313_ VDD=VDD Y=_0314_ VSS=VSS A1=net388
+ A2=_0312_
X_1481_ sg13cmos5l_nor2_1 $PINS A=net345 B=_0314_ Y=_0315_ VDD=VDD VSS=VSS
X_1482_ sg13cmos5l_a21oi_1 $PINS VSS=VSS VDD=VDD A1=net345 A2=_0311_ Y=_0316_
+ B1=_0315_
X_1483_ sg13cmos5l_a21oi_1 $PINS VSS=VSS VDD=VDD A1=net330 A2=_0316_ Y=_0317_
+ B1=net308
X_1484_ sg13cmos5l_nor2_1 $PINS A=\reg_out9[5] B=net327 Y=_0318_ VDD=VDD
+ VSS=VSS
X_1485_ sg13cmos5l_nor3_1 $PINS A=\reg_out10[5] B=net324 C=net321 Y=_0319_
+ VDD=VDD VSS=VSS
X_1486_ sg13cmos5l_o21ai_1 $PINS B1=net331 VDD=VDD Y=_0320_ VSS=VSS A1=_0318_
+ A2=_0319_
X_1487_ sg13cmos5l_nor2_1 $PINS A=\reg_out7[5] B=net320 Y=_0321_ VDD=VDD
+ VSS=VSS
X_1488_ sg13cmos5l_nor3_1 $PINS A=\reg_out8[5] B=net319 C=net318 Y=_0322_
+ VDD=VDD VSS=VSS
X_1489_ sg13cmos5l_o21ai_1 $PINS B1=net306 VDD=VDD Y=_0323_ VSS=VSS A1=_0321_
+ A2=_0322_
X_1490_ sg13cmos5l_nor2_1 $PINS A=\reg_out5[5] B=net328 Y=_0324_ VDD=VDD
+ VSS=VSS
X_1491_ sg13cmos5l_nor3_1 $PINS A=\reg_out6[5] B=net326 C=net322 Y=_0325_
+ VDD=VDD VSS=VSS
X_1492_ sg13cmos5l_o21ai_1 $PINS B1=net309 VDD=VDD Y=_0326_ VSS=VSS A1=_0324_
+ A2=_0325_
X_1493_ sg13cmos5l_nand4_1 $PINS B=_0320_ C=_0323_ A=net307 Y=_0327_ VDD=VDD
+ VSS=VSS D=_0326_
X_1494_ sg13cmos5l_a21o_1 $PINS A2=_0317_ A1=_0308_ B1=_0327_ X=_0328_ VDD=VDD
+ VSS=VSS
X_1495_ sg13cmos5l_nand2b_1 $PINS Y=_0329_ B=net304 A_N=\reg_out4[5] VDD=VDD
+ VSS=VSS
X_1496_ sg13cmos5l_a221oi_1 $PINS VDD=VDD VSS=VSS B2=_0329_ C1=_0296_ B1=net305
+ A1=\bias_gen_reg_dout[5] Y=_0330_ A2=net337
X_1497_ sg13cmos5l_a22oi_1 $PINS Y=_0037_ B1=_0328_ B2=_0330_ A2=_0300_
+ A1=_0297_ VDD=VDD VSS=VSS
X_1498_ sg13cmos5l_and3_1 $PINS X=_0331_ A=\reg_out1[6] B=net317 C=net316
+ VDD=VDD VSS=VSS
X_1499_ sg13cmos5l_a21oi_1 $PINS VSS=VSS VDD=VDD A1=\bias_gen_reg_dout[6]
+ A2=net338 Y=_0332_ B1=_0331_
X_1500_ sg13cmos5l_or2_1 $PINS VSS=VSS VDD=VDD X=_0333_ B=net315 A=\reg_out3[6]
X_1501_ sg13cmos5l_o21ai_1 $PINS B1=_0333_ VDD=VDD Y=_0334_ VSS=VSS
+ A1=\reg_out2[6] A2=net302
X_1502_ sg13cmos5l_or2_1 $PINS VSS=VSS VDD=VDD X=_0335_ B=_0334_ A=net303
X_1503_ sg13cmos5l_mux2_1 $PINS A0=\reg_out15[6] A1=\reg_out16[6] S=net335
+ X=_0336_ VDD=VDD VSS=VSS
X_1504_ sg13cmos5l_and2_1 $PINS A=net314 B=_0336_ X=_0337_ VDD=VDD VSS=VSS
X_1505_ sg13cmos5l_nand2_1 $PINS Y=_0338_ A=\reg_out14[6] B=_0721_ VDD=VDD
+ VSS=VSS
X_1506_ sg13cmos5l_nand2_1 $PINS Y=_0339_ A=net313 B=_0338_ VDD=VDD VSS=VSS
X_1507_ sg13cmos5l_inv_1 $PINS VDD=VDD Y=_0340_ A=\reg_out13[6] VSS=VSS
X_1508_ sg13cmos5l_nand2_1 $PINS Y=_0341_ A=\reg_out12[6] B=net334 VDD=VDD
+ VSS=VSS
X_1509_ sg13cmos5l_a22oi_1 $PINS Y=_0342_ B1=_0341_ B2=net312 A2=net311
+ A1=_0340_ VDD=VDD VSS=VSS
X_1510_ sg13cmos5l_o21ai_1 $PINS B1=_0342_ VDD=VDD Y=_0343_ VSS=VSS A1=_0337_
+ A2=_0339_
X_1511_ sg13cmos5l_inv_1 $PINS VDD=VDD Y=_0344_ A=\reg_out11[6] VSS=VSS
X_1512_ sg13cmos5l_o21ai_1 $PINS B1=net360 VDD=VDD Y=_0345_ VSS=VSS A1=_0344_
+ A2=net362
X_1513_ sg13cmos5l_o21ai_1 $PINS B1=_0345_ VDD=VDD Y=_0346_ VSS=VSS
+ A1=\reg_out9[6] A2=_0733_
X_1514_ sg13cmos5l_nor2_1 $PINS A=\reg_out9[6] B=net395 Y=_0347_ VDD=VDD
+ VSS=VSS
X_1515_ sg13cmos5l_nand3b_1 $PINS B=net390 C=\reg_out11[6] Y=_0348_ VDD=VDD
+ VSS=VSS A_N=net395
X_1516_ sg13cmos5l_o21ai_1 $PINS B1=_0348_ VDD=VDD Y=_0349_ VSS=VSS A1=net390
+ A2=_0347_
X_1517_ sg13cmos5l_nor2_1 $PINS A=net348 B=_0349_ Y=_0350_ VDD=VDD VSS=VSS
X_1518_ sg13cmos5l_a21oi_1 $PINS VSS=VSS VDD=VDD A1=net348 A2=_0346_ Y=_0351_
+ B1=_0350_
X_1519_ sg13cmos5l_a21oi_1 $PINS VSS=VSS VDD=VDD A1=_0730_ A2=_0351_ Y=_0352_
+ B1=_0771_
X_1520_ sg13cmos5l_nor2_1 $PINS A=\reg_out9[6] B=net327 Y=_0353_ VDD=VDD
+ VSS=VSS
X_1521_ sg13cmos5l_nor3_1 $PINS A=\reg_out10[6] B=net324 C=net321 Y=_0354_
+ VDD=VDD VSS=VSS
X_1522_ sg13cmos5l_o21ai_1 $PINS B1=net331 VDD=VDD Y=_0355_ VSS=VSS A1=_0353_
+ A2=_0354_
X_1523_ sg13cmos5l_nor2_1 $PINS A=\reg_out7[6] B=net320 Y=_0356_ VDD=VDD
+ VSS=VSS
X_1524_ sg13cmos5l_nor3_1 $PINS A=\reg_out8[6] B=net319 C=net318 Y=_0357_
+ VDD=VDD VSS=VSS
X_1525_ sg13cmos5l_o21ai_1 $PINS B1=net306 VDD=VDD Y=_0358_ VSS=VSS A1=_0356_
+ A2=_0357_
X_1526_ sg13cmos5l_nor2_1 $PINS A=\reg_out5[6] B=net328 Y=_0359_ VDD=VDD
+ VSS=VSS
X_1527_ sg13cmos5l_nor3_1 $PINS A=\reg_out6[6] B=net326 C=net322 Y=_0360_
+ VDD=VDD VSS=VSS
X_1528_ sg13cmos5l_o21ai_1 $PINS B1=net309 VDD=VDD Y=_0361_ VSS=VSS A1=_0359_
+ A2=_0360_
X_1529_ sg13cmos5l_nand4_1 $PINS B=_0355_ C=_0358_ A=net307 Y=_0362_ VDD=VDD
+ VSS=VSS D=_0361_
X_1530_ sg13cmos5l_a21o_1 $PINS A2=_0352_ A1=_0343_ B1=_0362_ X=_0363_ VDD=VDD
+ VSS=VSS
X_1531_ sg13cmos5l_nand2b_1 $PINS Y=_0364_ B=net304 A_N=\reg_out4[6] VDD=VDD
+ VSS=VSS
X_1532_ sg13cmos5l_a221oi_1 $PINS VDD=VDD VSS=VSS B2=_0364_ C1=_0331_ B1=net305
+ A1=\bias_gen_reg_dout[6] Y=_0365_ A2=net338
X_1533_ sg13cmos5l_a22oi_1 $PINS Y=_0038_ B1=_0363_ B2=_0365_ A2=_0335_
+ A1=_0332_ VDD=VDD VSS=VSS
X_1534_ sg13cmos5l_and3_1 $PINS X=_0366_ A=\reg_out1[7] B=net317 C=net316
+ VDD=VDD VSS=VSS
X_1535_ sg13cmos5l_a21oi_1 $PINS VSS=VSS VDD=VDD A1=\bias_gen_reg_dout[7]
+ A2=net338 Y=_0367_ B1=_0366_
X_1536_ sg13cmos5l_or2_1 $PINS VSS=VSS VDD=VDD X=_0368_ B=net315 A=\reg_out3[7]
X_1537_ sg13cmos5l_o21ai_1 $PINS B1=_0368_ VDD=VDD Y=_0369_ VSS=VSS
+ A1=\reg_out2[7] A2=net302
X_1538_ sg13cmos5l_or2_1 $PINS VSS=VSS VDD=VDD X=_0370_ B=_0369_ A=_0677_
X_1539_ sg13cmos5l_mux2_1 $PINS A0=\reg_out15[7] A1=\reg_out16[7] S=net335
+ X=_0371_ VDD=VDD VSS=VSS
X_1540_ sg13cmos5l_and2_1 $PINS A=net314 B=_0371_ X=_0372_ VDD=VDD VSS=VSS
X_1541_ sg13cmos5l_nand2_1 $PINS Y=_0373_ A=\reg_out14[7] B=_0721_ VDD=VDD
+ VSS=VSS
X_1542_ sg13cmos5l_nand2_1 $PINS Y=_0374_ A=net313 B=_0373_ VDD=VDD VSS=VSS
X_1543_ sg13cmos5l_inv_1 $PINS VDD=VDD Y=_0375_ A=\reg_out13[7] VSS=VSS
X_1544_ sg13cmos5l_nand2_1 $PINS Y=_0376_ A=\reg_out12[7] B=net334 VDD=VDD
+ VSS=VSS
X_1545_ sg13cmos5l_a22oi_1 $PINS Y=_0377_ B1=_0376_ B2=net312 A2=net311
+ A1=_0375_ VDD=VDD VSS=VSS
X_1546_ sg13cmos5l_o21ai_1 $PINS B1=_0377_ VDD=VDD Y=_0378_ VSS=VSS A1=_0372_
+ A2=_0374_
X_1547_ sg13cmos5l_inv_1 $PINS VDD=VDD Y=_0379_ A=\reg_out11[7] VSS=VSS
X_1548_ sg13cmos5l_o21ai_1 $PINS B1=net359 VDD=VDD Y=_0380_ VSS=VSS A1=_0379_
+ A2=net361
X_1549_ sg13cmos5l_o21ai_1 $PINS B1=_0380_ VDD=VDD Y=_0381_ VSS=VSS
+ A1=\reg_out9[7] A2=net357
X_1550_ sg13cmos5l_nor2_1 $PINS A=\reg_out9[7] B=net398 Y=_0382_ VDD=VDD
+ VSS=VSS
X_1551_ sg13cmos5l_nand3b_1 $PINS B=net393 C=\reg_out11[7] Y=_0383_ VDD=VDD
+ VSS=VSS A_N=net399
X_1552_ sg13cmos5l_o21ai_1 $PINS B1=_0383_ VDD=VDD Y=_0384_ VSS=VSS A1=net392
+ A2=_0382_
X_1553_ sg13cmos5l_nor2_1 $PINS A=net347 B=_0384_ Y=_0385_ VDD=VDD VSS=VSS
X_1554_ sg13cmos5l_a21oi_1 $PINS VSS=VSS VDD=VDD A1=net347 A2=_0381_ Y=_0386_
+ B1=_0385_
X_1555_ sg13cmos5l_a21oi_1 $PINS VSS=VSS VDD=VDD A1=net330 A2=_0386_ Y=_0387_
+ B1=net308
X_1556_ sg13cmos5l_nor2_1 $PINS A=\reg_out9[7] B=_0735_ Y=_0388_ VDD=VDD
+ VSS=VSS
X_1557_ sg13cmos5l_nor3_1 $PINS A=\reg_out10[7] B=net325 C=_0782_ Y=_0389_
+ VDD=VDD VSS=VSS
X_1558_ sg13cmos5l_o21ai_1 $PINS B1=net332 VDD=VDD Y=_0390_ VSS=VSS A1=_0388_
+ A2=_0389_
X_1559_ sg13cmos5l_nor2_1 $PINS A=\reg_out7[7] B=net320 Y=_0391_ VDD=VDD
+ VSS=VSS
X_1560_ sg13cmos5l_nor3_1 $PINS A=\reg_out8[7] B=net319 C=net318 Y=_0392_
+ VDD=VDD VSS=VSS
X_1561_ sg13cmos5l_o21ai_1 $PINS B1=net306 VDD=VDD Y=_0393_ VSS=VSS A1=_0391_
+ A2=_0392_
X_1562_ sg13cmos5l_nor2_1 $PINS A=\reg_out5[7] B=net329 Y=_0394_ VDD=VDD
+ VSS=VSS
X_1563_ sg13cmos5l_nor3_1 $PINS A=\reg_out6[7] B=_0780_ C=net323 Y=_0395_
+ VDD=VDD VSS=VSS
X_1564_ sg13cmos5l_o21ai_1 $PINS B1=net309 VDD=VDD Y=_0396_ VSS=VSS A1=_0394_
+ A2=_0395_
X_1565_ sg13cmos5l_nand4_1 $PINS B=_0390_ C=_0393_ A=net307 Y=_0397_ VDD=VDD
+ VSS=VSS D=_0396_
X_1566_ sg13cmos5l_a21o_1 $PINS A2=_0387_ A1=_0378_ B1=_0397_ X=_0398_ VDD=VDD
+ VSS=VSS
X_1567_ sg13cmos5l_nand2b_1 $PINS Y=_0399_ B=net304 A_N=\reg_out4[7] VDD=VDD
+ VSS=VSS
X_1568_ sg13cmos5l_a221oi_1 $PINS VDD=VDD VSS=VSS B2=_0399_ C1=_0366_ B1=net305
+ A1=\bias_gen_reg_dout[7] Y=_0400_ A2=net338
X_1569_ sg13cmos5l_a22oi_1 $PINS Y=_0039_ B1=_0398_ B2=_0400_ A2=_0370_
+ A1=_0367_ VDD=VDD VSS=VSS
X_1570_ sg13cmos5l_and3_1 $PINS X=_0401_ A=\reg_out1[8] B=net317 C=net316
+ VDD=VDD VSS=VSS
X_1571_ sg13cmos5l_a21oi_1 $PINS VSS=VSS VDD=VDD A1=\bias_gen_reg_dout[8]
+ A2=net338 Y=_0402_ B1=_0401_
X_1572_ sg13cmos5l_or2_1 $PINS VSS=VSS VDD=VDD X=_0403_ B=_0689_ A=\reg_out3[8]
X_1573_ sg13cmos5l_o21ai_1 $PINS B1=_0403_ VDD=VDD Y=_0404_ VSS=VSS
+ A1=\reg_out2[8] A2=net302
X_1574_ sg13cmos5l_or2_1 $PINS VSS=VSS VDD=VDD X=_0405_ B=_0404_ A=_0677_
X_1575_ sg13cmos5l_mux2_1 $PINS A0=\reg_out15[8] A1=\reg_out16[8] S=net335
+ X=_0406_ VDD=VDD VSS=VSS
X_1576_ sg13cmos5l_and2_1 $PINS A=net314 B=_0406_ X=_0407_ VDD=VDD VSS=VSS
X_1577_ sg13cmos5l_nand2_1 $PINS Y=_0408_ A=\reg_out14[8] B=_0721_ VDD=VDD
+ VSS=VSS
X_1578_ sg13cmos5l_nand2_1 $PINS Y=_0409_ A=net313 B=_0408_ VDD=VDD VSS=VSS
X_1579_ sg13cmos5l_inv_1 $PINS VDD=VDD Y=_0410_ A=\reg_out13[8] VSS=VSS
X_1580_ sg13cmos5l_nand2_1 $PINS Y=_0411_ A=\reg_out12[8] B=net334 VDD=VDD
+ VSS=VSS
X_1581_ sg13cmos5l_a22oi_1 $PINS Y=_0412_ B1=_0411_ B2=net312 A2=net311
+ A1=_0410_ VDD=VDD VSS=VSS
X_1582_ sg13cmos5l_o21ai_1 $PINS B1=_0412_ VDD=VDD Y=_0413_ VSS=VSS A1=_0407_
+ A2=_0409_
X_1583_ sg13cmos5l_inv_1 $PINS VDD=VDD Y=_0414_ A=\reg_out11[8] VSS=VSS
X_1584_ sg13cmos5l_o21ai_1 $PINS B1=net359 VDD=VDD Y=_0415_ VSS=VSS A1=_0414_
+ A2=net361
X_1585_ sg13cmos5l_o21ai_1 $PINS B1=_0415_ VDD=VDD Y=_0416_ VSS=VSS
+ A1=\reg_out9[8] A2=net357
X_1586_ sg13cmos5l_nor2_1 $PINS A=\reg_out9[8] B=net398 Y=_0417_ VDD=VDD
+ VSS=VSS
X_1587_ sg13cmos5l_nand3b_1 $PINS B=net393 C=\reg_out11[8] Y=_0418_ VDD=VDD
+ VSS=VSS A_N=net399
X_1588_ sg13cmos5l_o21ai_1 $PINS B1=_0418_ VDD=VDD Y=_0419_ VSS=VSS A1=net392
+ A2=_0417_
X_1589_ sg13cmos5l_nor2_1 $PINS A=net345 B=_0419_ Y=_0420_ VDD=VDD VSS=VSS
X_1590_ sg13cmos5l_a21oi_1 $PINS VSS=VSS VDD=VDD A1=net345 A2=_0416_ Y=_0421_
+ B1=_0420_
X_1591_ sg13cmos5l_a21oi_1 $PINS VSS=VSS VDD=VDD A1=net330 A2=_0421_ Y=_0422_
+ B1=net308
X_1592_ sg13cmos5l_nor2_1 $PINS A=\reg_out9[8] B=net327 Y=_0423_ VDD=VDD
+ VSS=VSS
X_1593_ sg13cmos5l_nor3_1 $PINS A=\reg_out10[8] B=net324 C=net321 Y=_0424_
+ VDD=VDD VSS=VSS
X_1594_ sg13cmos5l_o21ai_1 $PINS B1=net331 VDD=VDD Y=_0425_ VSS=VSS A1=_0423_
+ A2=_0424_
X_1595_ sg13cmos5l_nor2_1 $PINS A=\reg_out7[8] B=net320 Y=_0426_ VDD=VDD
+ VSS=VSS
X_1596_ sg13cmos5l_nor3_1 $PINS A=\reg_out8[8] B=net319 C=net318 Y=_0427_
+ VDD=VDD VSS=VSS
X_1597_ sg13cmos5l_o21ai_1 $PINS B1=net306 VDD=VDD Y=_0428_ VSS=VSS A1=_0426_
+ A2=_0427_
X_1598_ sg13cmos5l_nor2_1 $PINS A=\reg_out5[8] B=net328 Y=_0429_ VDD=VDD
+ VSS=VSS
X_1599_ sg13cmos5l_nor3_1 $PINS A=\reg_out6[8] B=net326 C=net322 Y=_0430_
+ VDD=VDD VSS=VSS
X_1600_ sg13cmos5l_o21ai_1 $PINS B1=net309 VDD=VDD Y=_0431_ VSS=VSS A1=_0429_
+ A2=_0430_
X_1601_ sg13cmos5l_nand4_1 $PINS B=_0425_ C=_0428_ A=net307 Y=_0432_ VDD=VDD
+ VSS=VSS D=_0431_
X_1602_ sg13cmos5l_a21o_1 $PINS A2=_0422_ A1=_0413_ B1=_0432_ X=_0433_ VDD=VDD
+ VSS=VSS
X_1603_ sg13cmos5l_nand2b_1 $PINS Y=_0434_ B=net304 A_N=\reg_out4[8] VDD=VDD
+ VSS=VSS
X_1604_ sg13cmos5l_a221oi_1 $PINS VDD=VDD VSS=VSS B2=_0434_ C1=_0401_ B1=net305
+ A1=\bias_gen_reg_dout[8] Y=_0435_ A2=net338
X_1605_ sg13cmos5l_a22oi_1 $PINS Y=_0040_ B1=_0433_ B2=_0435_ A2=_0405_
+ A1=_0402_ VDD=VDD VSS=VSS
X_1606_ sg13cmos5l_and3_1 $PINS X=_0436_ A=\reg_out1[9] B=net317 C=net316
+ VDD=VDD VSS=VSS
X_1607_ sg13cmos5l_a21oi_1 $PINS VSS=VSS VDD=VDD A1=\bias_gen_reg_dout[9]
+ A2=net338 Y=_0437_ B1=_0436_
X_1608_ sg13cmos5l_or2_1 $PINS VSS=VSS VDD=VDD X=_0438_ B=_0689_ A=\reg_out3[9]
X_1609_ sg13cmos5l_o21ai_1 $PINS B1=_0438_ VDD=VDD Y=_0439_ VSS=VSS
+ A1=\reg_out2[9] A2=net302
X_1610_ sg13cmos5l_or2_1 $PINS VSS=VSS VDD=VDD X=_0440_ B=_0439_ A=_0677_
X_1611_ sg13cmos5l_mux2_1 $PINS A0=\reg_out15[9] A1=\reg_out16[9] S=net335
+ X=_0441_ VDD=VDD VSS=VSS
X_1612_ sg13cmos5l_and2_1 $PINS A=net314 B=_0441_ X=_0442_ VDD=VDD VSS=VSS
X_1613_ sg13cmos5l_nand2_1 $PINS Y=_0443_ A=\reg_out14[9] B=_0721_ VDD=VDD
+ VSS=VSS
X_1614_ sg13cmos5l_nand2_1 $PINS Y=_0444_ A=net313 B=_0443_ VDD=VDD VSS=VSS
X_1615_ sg13cmos5l_inv_1 $PINS VDD=VDD Y=_0445_ A=\reg_out13[9] VSS=VSS
X_1616_ sg13cmos5l_nand2_1 $PINS Y=_0446_ A=\reg_out12[9] B=net334 VDD=VDD
+ VSS=VSS
X_1617_ sg13cmos5l_a22oi_1 $PINS Y=_0447_ B1=_0446_ B2=net312 A2=net311
+ A1=_0445_ VDD=VDD VSS=VSS
X_1618_ sg13cmos5l_o21ai_1 $PINS B1=_0447_ VDD=VDD Y=_0448_ VSS=VSS A1=_0442_
+ A2=_0444_
X_1619_ sg13cmos5l_inv_1 $PINS VDD=VDD Y=_0449_ A=\reg_out11[9] VSS=VSS
X_1620_ sg13cmos5l_o21ai_1 $PINS B1=net359 VDD=VDD Y=_0450_ VSS=VSS A1=_0449_
+ A2=net361
X_1621_ sg13cmos5l_o21ai_1 $PINS B1=_0450_ VDD=VDD Y=_0451_ VSS=VSS
+ A1=\reg_out9[9] A2=net357
X_1622_ sg13cmos5l_nor2_1 $PINS A=\reg_out9[9] B=net398 Y=_0452_ VDD=VDD
+ VSS=VSS
X_1623_ sg13cmos5l_nand3b_1 $PINS B=net393 C=\reg_out11[9] Y=_0453_ VDD=VDD
+ VSS=VSS A_N=net399
X_1624_ sg13cmos5l_o21ai_1 $PINS B1=_0453_ VDD=VDD Y=_0454_ VSS=VSS A1=net392
+ A2=_0452_
X_1625_ sg13cmos5l_nor2_1 $PINS A=net346 B=_0454_ Y=_0455_ VDD=VDD VSS=VSS
X_1626_ sg13cmos5l_a21oi_1 $PINS VSS=VSS VDD=VDD A1=net347 A2=_0451_ Y=_0456_
+ B1=_0455_
X_1627_ sg13cmos5l_a21oi_1 $PINS VSS=VSS VDD=VDD A1=net330 A2=_0456_ Y=_0457_
+ B1=net308
X_1628_ sg13cmos5l_nor2_1 $PINS A=\reg_out9[9] B=net327 Y=_0458_ VDD=VDD
+ VSS=VSS
X_1629_ sg13cmos5l_nor3_1 $PINS A=\reg_out10[9] B=net324 C=net321 Y=_0459_
+ VDD=VDD VSS=VSS
X_1630_ sg13cmos5l_o21ai_1 $PINS B1=net331 VDD=VDD Y=_0460_ VSS=VSS A1=_0458_
+ A2=_0459_
X_1631_ sg13cmos5l_nor2_1 $PINS A=\reg_out7[9] B=net320 Y=_0461_ VDD=VDD
+ VSS=VSS
X_1632_ sg13cmos5l_nor3_1 $PINS A=\reg_out8[9] B=net319 C=net318 Y=_0462_
+ VDD=VDD VSS=VSS
X_1633_ sg13cmos5l_o21ai_1 $PINS B1=net306 VDD=VDD Y=_0463_ VSS=VSS A1=_0461_
+ A2=_0462_
X_1634_ sg13cmos5l_nor2_1 $PINS A=\reg_out5[9] B=net328 Y=_0464_ VDD=VDD
+ VSS=VSS
X_1635_ sg13cmos5l_nor3_1 $PINS A=\reg_out6[9] B=net326 C=net322 Y=_0465_
+ VDD=VDD VSS=VSS
X_1636_ sg13cmos5l_o21ai_1 $PINS B1=net309 VDD=VDD Y=_0466_ VSS=VSS A1=_0464_
+ A2=_0465_
X_1637_ sg13cmos5l_nand4_1 $PINS B=_0460_ C=_0463_ A=net307 Y=_0467_ VDD=VDD
+ VSS=VSS D=_0466_
X_1638_ sg13cmos5l_a21o_1 $PINS A2=_0457_ A1=_0448_ B1=_0467_ X=_0468_ VDD=VDD
+ VSS=VSS
X_1639_ sg13cmos5l_nand2b_1 $PINS Y=_0469_ B=net304 A_N=\reg_out4[9] VDD=VDD
+ VSS=VSS
X_1640_ sg13cmos5l_a221oi_1 $PINS VDD=VDD VSS=VSS B2=_0469_ C1=_0436_ B1=net305
+ A1=\bias_gen_reg_dout[9] Y=_0470_ A2=net338
X_1641_ sg13cmos5l_a22oi_1 $PINS Y=_0041_ B1=_0468_ B2=_0470_ A2=_0440_
+ A1=_0437_ VDD=VDD VSS=VSS
X_1642_ sg13cmos5l_nand2_1 $PINS Y=_0471_ A=_0694_ B=net352 VDD=VDD VSS=VSS
X_1643_ sg13cmos5l_o21ai_1 $PINS B1=_0471_ VDD=VDD Y=_0472_ VSS=VSS A1=_0665_
+ A2=net352
X_1644_ sg13cmos5l_nand2_1 $PINS Y=_0473_ A=net349 B=_0726_ VDD=VDD VSS=VSS
X_1645_ sg13cmos5l_o21ai_1 $PINS B1=_0473_ VDD=VDD Y=_0474_ VSS=VSS A1=net350
+ A2=_0739_
X_1646_ sg13cmos5l_nand2_1 $PINS Y=_0475_ A=_0472_ B=_0474_ VDD=VDD VSS=VSS
X_1647_ sg13cmos5l_nand2_1 $PINS Y=_0476_ A=\u_spi_core.bit_cnt[4] B=_0621_
+ VDD=VDD VSS=VSS
X_1648_ sg13cmos5l_nor4_1 $PINS A=\u_spi_core.shift_in[28]
+ B=\u_spi_core.shift_in[30] C=_0476_ D=_0624_ Y=_0477_ VDD=VDD VSS=VSS
X_1649_ sg13cmos5l_nor2b_2 $PINS A=\u_spi_core.shift_in[29] B_N=_0477_ Y=_0478_
+ VDD=VDD VSS=VSS
X_1650_ sg13cmos5l_nand2b_1 $PINS Y=_0479_ B=_0478_ A_N=_0780_ VDD=VDD VSS=VSS
X_1651_ sg13cmos5l_or2_1 $PINS VSS=VSS VDD=VDD X=_0480_ B=_0479_ A=_0475_
X_1653_ sg13cmos5l_mux2_1 $PINS A0=mosi A1=\reg_out10[0] S=net299 X=_0042_
+ VDD=VDD VSS=VSS
X_1654_ sg13cmos5l_mux2_1 $PINS A0=\bias_gen_reg_din[10] A1=\reg_out10[10]
+ S=net299 X=_0043_ VDD=VDD VSS=VSS
X_1655_ sg13cmos5l_mux2_1 $PINS A0=net400 A1=\reg_out10[1] S=net299 X=_0044_
+ VDD=VDD VSS=VSS
X_1656_ sg13cmos5l_mux2_1 $PINS A0=net388 A1=\reg_out10[2] S=net299 X=_0045_
+ VDD=VDD VSS=VSS
X_1657_ sg13cmos5l_mux2_1 $PINS A0=net386 A1=\reg_out10[3] S=_0480_ X=_0046_
+ VDD=VDD VSS=VSS
X_1658_ sg13cmos5l_mux2_1 $PINS A0=net382 A1=\reg_out10[4] S=_0480_ X=_0047_
+ VDD=VDD VSS=VSS
X_1659_ sg13cmos5l_mux2_1 $PINS A0=net381 A1=\reg_out10[5] S=net299 X=_0048_
+ VDD=VDD VSS=VSS
X_1660_ sg13cmos5l_mux2_1 $PINS A0=net379 A1=\reg_out10[6] S=net299 X=_0049_
+ VDD=VDD VSS=VSS
X_1661_ sg13cmos5l_mux2_1 $PINS A0=net376 A1=\reg_out10[7] S=_0480_ X=_0050_
+ VDD=VDD VSS=VSS
X_1662_ sg13cmos5l_mux2_1 $PINS A0=\bias_gen_reg_din[8] A1=\reg_out10[8]
+ S=net299 X=_0051_ VDD=VDD VSS=VSS
X_1663_ sg13cmos5l_mux2_1 $PINS A0=\bias_gen_reg_din[9] A1=\reg_out10[9]
+ S=net299 X=_0052_ VDD=VDD VSS=VSS
X_1664_ sg13cmos5l_nand2_1 $PINS Y=_0482_ A=_0793_ B=_0478_ VDD=VDD VSS=VSS
X_1665_ sg13cmos5l_or2_1 $PINS VSS=VSS VDD=VDD X=_0483_ B=_0482_ A=_0475_
X_1667_ sg13cmos5l_mux2_1 $PINS A0=mosi A1=\reg_out11[0] S=net298 X=_0053_
+ VDD=VDD VSS=VSS
X_1668_ sg13cmos5l_mux2_1 $PINS A0=net401 A1=\reg_out11[10] S=_0483_ X=_0054_
+ VDD=VDD VSS=VSS
X_1669_ sg13cmos5l_mux2_1 $PINS A0=net395 A1=\reg_out11[1] S=_0483_ X=_0055_
+ VDD=VDD VSS=VSS
X_1670_ sg13cmos5l_mux2_1 $PINS A0=net390 A1=\reg_out11[2] S=_0483_ X=_0056_
+ VDD=VDD VSS=VSS
X_1671_ sg13cmos5l_mux2_1 $PINS A0=net386 A1=\reg_out11[3] S=net298 X=_0057_
+ VDD=VDD VSS=VSS
X_1672_ sg13cmos5l_mux2_1 $PINS A0=net382 A1=\reg_out11[4] S=net298 X=_0058_
+ VDD=VDD VSS=VSS
X_1673_ sg13cmos5l_mux2_1 $PINS A0=net381 A1=\reg_out11[5] S=net298 X=_0059_
+ VDD=VDD VSS=VSS
X_1674_ sg13cmos5l_mux2_1 $PINS A0=net379 A1=\reg_out11[6] S=net298 X=_0060_
+ VDD=VDD VSS=VSS
X_1675_ sg13cmos5l_mux2_1 $PINS A0=net376 A1=\reg_out11[7] S=net298 X=_0061_
+ VDD=VDD VSS=VSS
X_1676_ sg13cmos5l_mux2_1 $PINS A0=net374 A1=\reg_out11[8] S=net298 X=_0062_
+ VDD=VDD VSS=VSS
X_1677_ sg13cmos5l_mux2_1 $PINS A0=net372 A1=\reg_out11[9] S=net298 X=_0063_
+ VDD=VDD VSS=VSS
X_1678_ sg13cmos5l_nand3_1 $PINS B=_0472_ C=_0478_ A=_0741_ Y=_0485_ VDD=VDD
+ VSS=VSS
X_1680_ sg13cmos5l_mux2_1 $PINS A0=mosi A1=\reg_out12[0] S=net301 X=_0064_
+ VDD=VDD VSS=VSS
X_1681_ sg13cmos5l_mux2_1 $PINS A0=net401 A1=\reg_out12[10] S=_0485_ X=_0065_
+ VDD=VDD VSS=VSS
X_1682_ sg13cmos5l_mux2_1 $PINS A0=net395 A1=\reg_out12[1] S=net301 X=_0066_
+ VDD=VDD VSS=VSS
X_1683_ sg13cmos5l_mux2_1 $PINS A0=net390 A1=\reg_out12[2] S=net301 X=_0067_
+ VDD=VDD VSS=VSS
X_1684_ sg13cmos5l_mux2_1 $PINS A0=net387 A1=\reg_out12[3] S=_0485_ X=_0068_
+ VDD=VDD VSS=VSS
X_1685_ sg13cmos5l_mux2_1 $PINS A0=net382 A1=\reg_out12[4] S=_0485_ X=_0069_
+ VDD=VDD VSS=VSS
X_1686_ sg13cmos5l_mux2_1 $PINS A0=net381 A1=\reg_out12[5] S=net301 X=_0070_
+ VDD=VDD VSS=VSS
X_1687_ sg13cmos5l_mux2_1 $PINS A0=net379 A1=\reg_out12[6] S=net301 X=_0071_
+ VDD=VDD VSS=VSS
X_1688_ sg13cmos5l_mux2_1 $PINS A0=net376 A1=\reg_out12[7] S=net301 X=_0072_
+ VDD=VDD VSS=VSS
X_1689_ sg13cmos5l_mux2_1 $PINS A0=net374 A1=\reg_out12[8] S=net301 X=_0073_
+ VDD=VDD VSS=VSS
X_1690_ sg13cmos5l_mux2_1 $PINS A0=net372 A1=\reg_out12[9] S=net301 X=_0074_
+ VDD=VDD VSS=VSS
X_1691_ sg13cmos5l_nor2_1 $PINS A=net349 B=_0717_ Y=_0487_ VDD=VDD VSS=VSS
X_1692_ sg13cmos5l_nor2_1 $PINS A=net352 B=_0696_ Y=_0488_ VDD=VDD VSS=VSS
X_1693_ sg13cmos5l_o21ai_1 $PINS B1=_0472_ VDD=VDD Y=_0489_ VSS=VSS A1=_0487_
+ A2=_0488_
X_1694_ sg13cmos5l_and2_1 $PINS A=_0782_ B=_0478_ X=_0490_ VDD=VDD VSS=VSS
X_1695_ sg13cmos5l_nand2b_1 $PINS Y=_0491_ B=_0490_ A_N=_0489_ VDD=VDD VSS=VSS
X_1697_ sg13cmos5l_mux2_1 $PINS A0=mosi A1=\reg_out13[0] S=net297 X=_0075_
+ VDD=VDD VSS=VSS
X_1698_ sg13cmos5l_mux2_1 $PINS A0=net401 A1=\reg_out13[10] S=_0491_ X=_0076_
+ VDD=VDD VSS=VSS
X_1699_ sg13cmos5l_mux2_1 $PINS A0=net395 A1=\reg_out13[1] S=net297 X=_0077_
+ VDD=VDD VSS=VSS
X_1700_ sg13cmos5l_mux2_1 $PINS A0=net390 A1=\reg_out13[2] S=net297 X=_0078_
+ VDD=VDD VSS=VSS
X_1701_ sg13cmos5l_mux2_1 $PINS A0=net387 A1=\reg_out13[3] S=_0491_ X=_0079_
+ VDD=VDD VSS=VSS
X_1702_ sg13cmos5l_mux2_1 $PINS A0=net382 A1=\reg_out13[4] S=_0491_ X=_0080_
+ VDD=VDD VSS=VSS
X_1703_ sg13cmos5l_mux2_1 $PINS A0=net381 A1=\reg_out13[5] S=net297 X=_0081_
+ VDD=VDD VSS=VSS
X_1704_ sg13cmos5l_mux2_1 $PINS A0=net379 A1=\reg_out13[6] S=net297 X=_0082_
+ VDD=VDD VSS=VSS
X_1705_ sg13cmos5l_mux2_1 $PINS A0=net376 A1=\reg_out13[7] S=net297 X=_0083_
+ VDD=VDD VSS=VSS
X_1706_ sg13cmos5l_mux2_1 $PINS A0=net374 A1=\reg_out13[8] S=net297 X=_0084_
+ VDD=VDD VSS=VSS
X_1707_ sg13cmos5l_mux2_1 $PINS A0=net372 A1=\reg_out13[9] S=net297 X=_0085_
+ VDD=VDD VSS=VSS
X_1708_ sg13cmos5l_or2_1 $PINS VSS=VSS VDD=VDD X=_0493_ B=_0489_ A=_0479_
X_1710_ sg13cmos5l_mux2_1 $PINS A0=mosi A1=\reg_out14[0] S=net296 X=_0086_
+ VDD=VDD VSS=VSS
X_1711_ sg13cmos5l_mux2_1 $PINS A0=net401 A1=\reg_out14[10] S=_0493_ X=_0087_
+ VDD=VDD VSS=VSS
X_1712_ sg13cmos5l_mux2_1 $PINS A0=net396 A1=\reg_out14[1] S=net296 X=_0088_
+ VDD=VDD VSS=VSS
X_1713_ sg13cmos5l_mux2_1 $PINS A0=net389 A1=\reg_out14[2] S=net296 X=_0089_
+ VDD=VDD VSS=VSS
X_1714_ sg13cmos5l_mux2_1 $PINS A0=net387 A1=\reg_out14[3] S=_0493_ X=_0090_
+ VDD=VDD VSS=VSS
X_1715_ sg13cmos5l_mux2_1 $PINS A0=net382 A1=\reg_out14[4] S=_0493_ X=_0091_
+ VDD=VDD VSS=VSS
X_1716_ sg13cmos5l_mux2_1 $PINS A0=net381 A1=\reg_out14[5] S=net296 X=_0092_
+ VDD=VDD VSS=VSS
X_1717_ sg13cmos5l_mux2_1 $PINS A0=net379 A1=\reg_out14[6] S=net296 X=_0093_
+ VDD=VDD VSS=VSS
X_1718_ sg13cmos5l_mux2_1 $PINS A0=net376 A1=\reg_out14[7] S=net296 X=_0094_
+ VDD=VDD VSS=VSS
X_1719_ sg13cmos5l_mux2_1 $PINS A0=net374 A1=\reg_out14[8] S=net296 X=_0095_
+ VDD=VDD VSS=VSS
X_1720_ sg13cmos5l_mux2_1 $PINS A0=net372 A1=\reg_out14[9] S=net296 X=_0096_
+ VDD=VDD VSS=VSS
X_1721_ sg13cmos5l_or2_1 $PINS VSS=VSS VDD=VDD X=_0495_ B=_0489_ A=_0482_
X_1723_ sg13cmos5l_mux2_1 $PINS A0=mosi A1=\reg_out15[0] S=net295 X=_0097_
+ VDD=VDD VSS=VSS
X_1724_ sg13cmos5l_mux2_1 $PINS A0=net401 A1=\reg_out15[10] S=_0495_ X=_0098_
+ VDD=VDD VSS=VSS
X_1725_ sg13cmos5l_mux2_1 $PINS A0=net395 A1=\reg_out15[1] S=net295 X=_0099_
+ VDD=VDD VSS=VSS
X_1726_ sg13cmos5l_mux2_1 $PINS A0=net389 A1=\reg_out15[2] S=net295 X=_0100_
+ VDD=VDD VSS=VSS
X_1727_ sg13cmos5l_mux2_1 $PINS A0=net387 A1=\reg_out15[3] S=_0495_ X=_0101_
+ VDD=VDD VSS=VSS
X_1728_ sg13cmos5l_mux2_1 $PINS A0=net382 A1=\reg_out15[4] S=_0495_ X=_0102_
+ VDD=VDD VSS=VSS
X_1729_ sg13cmos5l_mux2_1 $PINS A0=net381 A1=\reg_out15[5] S=net295 X=_0103_
+ VDD=VDD VSS=VSS
X_1730_ sg13cmos5l_mux2_1 $PINS A0=net379 A1=\reg_out15[6] S=net295 X=_0104_
+ VDD=VDD VSS=VSS
X_1731_ sg13cmos5l_mux2_1 $PINS A0=net376 A1=\reg_out15[7] S=net295 X=_0105_
+ VDD=VDD VSS=VSS
X_1732_ sg13cmos5l_mux2_1 $PINS A0=net374 A1=\reg_out15[8] S=net295 X=_0106_
+ VDD=VDD VSS=VSS
X_1733_ sg13cmos5l_mux2_1 $PINS A0=net372 A1=\reg_out15[9] S=net295 X=_0107_
+ VDD=VDD VSS=VSS
X_1734_ sg13cmos5l_nand2b_1 $PINS Y=_0497_ B=_0478_ A_N=_0791_ VDD=VDD VSS=VSS
X_1735_ sg13cmos5l_or2_1 $PINS VSS=VSS VDD=VDD X=_0498_ B=_0497_ A=_0489_
X_1737_ sg13cmos5l_mux2_1 $PINS A0=mosi A1=\reg_out16[0] S=net294 X=_0108_
+ VDD=VDD VSS=VSS
X_1738_ sg13cmos5l_mux2_1 $PINS A0=net401 A1=\reg_out16[10] S=_0498_ X=_0109_
+ VDD=VDD VSS=VSS
X_1739_ sg13cmos5l_mux2_1 $PINS A0=net395 A1=\reg_out16[1] S=net294 X=_0110_
+ VDD=VDD VSS=VSS
X_1740_ sg13cmos5l_mux2_1 $PINS A0=net389 A1=\reg_out16[2] S=net294 X=_0111_
+ VDD=VDD VSS=VSS
X_1741_ sg13cmos5l_mux2_1 $PINS A0=net387 A1=\reg_out16[3] S=_0498_ X=_0112_
+ VDD=VDD VSS=VSS
X_1742_ sg13cmos5l_mux2_1 $PINS A0=net382 A1=\reg_out16[4] S=_0498_ X=_0113_
+ VDD=VDD VSS=VSS
X_1743_ sg13cmos5l_mux2_1 $PINS A0=net381 A1=\reg_out16[5] S=net294 X=_0114_
+ VDD=VDD VSS=VSS
X_1744_ sg13cmos5l_mux2_1 $PINS A0=net379 A1=\reg_out16[6] S=net294 X=_0115_
+ VDD=VDD VSS=VSS
X_1745_ sg13cmos5l_mux2_1 $PINS A0=net376 A1=\reg_out16[7] S=net294 X=_0116_
+ VDD=VDD VSS=VSS
X_1746_ sg13cmos5l_mux2_1 $PINS A0=net374 A1=\reg_out16[8] S=net294 X=_0117_
+ VDD=VDD VSS=VSS
X_1747_ sg13cmos5l_mux2_1 $PINS A0=net372 A1=\reg_out16[9] S=net294 X=_0118_
+ VDD=VDD VSS=VSS
X_1748_ sg13cmos5l_nand2_1 $PINS Y=_0500_ A=_0666_ B=net344 VDD=VDD VSS=VSS
X_1749_ sg13cmos5l_o21ai_1 $PINS B1=_0500_ VDD=VDD Y=_0501_ VSS=VSS A1=_0681_
+ A2=net344
X_1750_ sg13cmos5l_nand2_1 $PINS Y=_0502_ A=_0478_ B=_0501_ VDD=VDD VSS=VSS
X_1751_ sg13cmos5l_nor2_1 $PINS A=net329 B=_0502_ Y=_0503_ VDD=VDD VSS=VSS
X_1753_ sg13cmos5l_mux2_1 $PINS A0=\reg_out1[0] A1=mosi S=net293 X=_0119_
+ VDD=VDD VSS=VSS
X_1754_ sg13cmos5l_mux2_1 $PINS A0=\reg_out1[10] A1=net402 S=net293 X=_0120_
+ VDD=VDD VSS=VSS
X_1755_ sg13cmos5l_mux2_1 $PINS A0=\reg_out1[1] A1=net397 S=net293 X=_0121_
+ VDD=VDD VSS=VSS
X_1756_ sg13cmos5l_mux2_1 $PINS A0=\reg_out1[2] A1=net391 S=net293 X=_0122_
+ VDD=VDD VSS=VSS
X_1757_ sg13cmos5l_mux2_1 $PINS A0=\reg_out1[3] A1=net385 S=net293 X=_0123_
+ VDD=VDD VSS=VSS
X_1758_ sg13cmos5l_mux2_1 $PINS A0=\reg_out1[4] A1=net384 S=net293 X=_0124_
+ VDD=VDD VSS=VSS
X_1759_ sg13cmos5l_mux2_1 $PINS A0=\reg_out1[5] A1=net380 S=_0503_ X=_0125_
+ VDD=VDD VSS=VSS
X_1760_ sg13cmos5l_mux2_1 $PINS A0=\reg_out1[6] A1=net378 S=net293 X=_0126_
+ VDD=VDD VSS=VSS
X_1761_ sg13cmos5l_mux2_1 $PINS A0=\reg_out1[7] A1=net377 S=_0503_ X=_0127_
+ VDD=VDD VSS=VSS
X_1762_ sg13cmos5l_mux2_1 $PINS A0=\reg_out1[8] A1=net375 S=_0503_ X=_0128_
+ VDD=VDD VSS=VSS
X_1763_ sg13cmos5l_mux2_1 $PINS A0=\reg_out1[9] A1=net373 S=_0503_ X=_0129_
+ VDD=VDD VSS=VSS
X_1764_ sg13cmos5l_nor2_1 $PINS A=_0780_ B=_0502_ Y=_0505_ VDD=VDD VSS=VSS
X_1766_ sg13cmos5l_mux2_1 $PINS A0=\reg_out2[0] A1=mosi S=net292 X=_0130_
+ VDD=VDD VSS=VSS
X_1767_ sg13cmos5l_mux2_1 $PINS A0=\reg_out2[10] A1=net402 S=_0505_ X=_0131_
+ VDD=VDD VSS=VSS
X_1768_ sg13cmos5l_mux2_1 $PINS A0=\reg_out2[1] A1=net397 S=_0505_ X=_0132_
+ VDD=VDD VSS=VSS
X_1769_ sg13cmos5l_mux2_1 $PINS A0=\reg_out2[2] A1=net391 S=net292 X=_0133_
+ VDD=VDD VSS=VSS
X_1770_ sg13cmos5l_mux2_1 $PINS A0=\reg_out2[3] A1=net385 S=_0505_ X=_0134_
+ VDD=VDD VSS=VSS
X_1771_ sg13cmos5l_mux2_1 $PINS A0=\reg_out2[4] A1=net384 S=net292 X=_0135_
+ VDD=VDD VSS=VSS
X_1772_ sg13cmos5l_mux2_1 $PINS A0=\reg_out2[5] A1=net380 S=net292 X=_0136_
+ VDD=VDD VSS=VSS
X_1773_ sg13cmos5l_mux2_1 $PINS A0=\reg_out2[6] A1=net378 S=net292 X=_0137_
+ VDD=VDD VSS=VSS
X_1774_ sg13cmos5l_mux2_1 $PINS A0=\reg_out2[7] A1=net377 S=net292 X=_0138_
+ VDD=VDD VSS=VSS
X_1775_ sg13cmos5l_mux2_1 $PINS A0=\reg_out2[8] A1=net375 S=net292 X=_0139_
+ VDD=VDD VSS=VSS
X_1776_ sg13cmos5l_mux2_1 $PINS A0=\reg_out2[9] A1=net373 S=net292 X=_0140_
+ VDD=VDD VSS=VSS
X_1777_ sg13cmos5l_nor2_1 $PINS A=net320 B=_0502_ Y=_0507_ VDD=VDD VSS=VSS
X_1779_ sg13cmos5l_mux2_1 $PINS A0=\reg_out3[0] A1=mosi S=net291 X=_0141_
+ VDD=VDD VSS=VSS
X_1780_ sg13cmos5l_mux2_1 $PINS A0=\reg_out3[10] A1=net402 S=_0507_ X=_0142_
+ VDD=VDD VSS=VSS
X_1781_ sg13cmos5l_mux2_1 $PINS A0=\reg_out3[1] A1=net397 S=net291 X=_0143_
+ VDD=VDD VSS=VSS
X_1782_ sg13cmos5l_mux2_1 $PINS A0=\reg_out3[2] A1=net391 S=net291 X=_0144_
+ VDD=VDD VSS=VSS
X_1783_ sg13cmos5l_mux2_1 $PINS A0=\reg_out3[3] A1=net385 S=_0507_ X=_0145_
+ VDD=VDD VSS=VSS
X_1784_ sg13cmos5l_mux2_1 $PINS A0=\reg_out3[4] A1=net384 S=_0507_ X=_0146_
+ VDD=VDD VSS=VSS
X_1785_ sg13cmos5l_mux2_1 $PINS A0=\reg_out3[5] A1=net380 S=net291 X=_0147_
+ VDD=VDD VSS=VSS
X_1786_ sg13cmos5l_mux2_1 $PINS A0=\reg_out3[6] A1=net378 S=net291 X=_0148_
+ VDD=VDD VSS=VSS
X_1787_ sg13cmos5l_mux2_1 $PINS A0=\reg_out3[7] A1=net377 S=net291 X=_0149_
+ VDD=VDD VSS=VSS
X_1788_ sg13cmos5l_mux2_1 $PINS A0=\reg_out3[8] A1=net375 S=net291 X=_0150_
+ VDD=VDD VSS=VSS
X_1789_ sg13cmos5l_mux2_1 $PINS A0=\reg_out3[9] A1=net373 S=net291 X=_0151_
+ VDD=VDD VSS=VSS
X_1790_ sg13cmos5l_nand2b_1 $PINS Y=_0509_ B=_0478_ A_N=_0776_ VDD=VDD VSS=VSS
X_1792_ sg13cmos5l_mux2_1 $PINS A0=mosi A1=\reg_out4[0] S=_0509_ X=_0152_
+ VDD=VDD VSS=VSS
X_1793_ sg13cmos5l_mux2_1 $PINS A0=net402 A1=\reg_out4[10] S=net300 X=_0153_
+ VDD=VDD VSS=VSS
X_1794_ sg13cmos5l_mux2_1 $PINS A0=net397 A1=\reg_out4[1] S=_0509_ X=_0154_
+ VDD=VDD VSS=VSS
X_1795_ sg13cmos5l_mux2_1 $PINS A0=net391 A1=\reg_out4[2] S=_0509_ X=_0155_
+ VDD=VDD VSS=VSS
X_1796_ sg13cmos5l_mux2_1 $PINS A0=net385 A1=\reg_out4[3] S=net300 X=_0156_
+ VDD=VDD VSS=VSS
X_1797_ sg13cmos5l_mux2_1 $PINS A0=net384 A1=\reg_out4[4] S=net300 X=_0157_
+ VDD=VDD VSS=VSS
X_1798_ sg13cmos5l_mux2_1 $PINS A0=net380 A1=\reg_out4[5] S=net300 X=_0158_
+ VDD=VDD VSS=VSS
X_1799_ sg13cmos5l_mux2_1 $PINS A0=net378 A1=\reg_out4[6] S=net300 X=_0159_
+ VDD=VDD VSS=VSS
X_1800_ sg13cmos5l_mux2_1 $PINS A0=net377 A1=\reg_out4[7] S=net300 X=_0160_
+ VDD=VDD VSS=VSS
X_1801_ sg13cmos5l_mux2_1 $PINS A0=net375 A1=\reg_out4[8] S=net300 X=_0161_
+ VDD=VDD VSS=VSS
X_1802_ sg13cmos5l_mux2_1 $PINS A0=net373 A1=\reg_out4[9] S=net300 X=_0162_
+ VDD=VDD VSS=VSS
X_1803_ sg13cmos5l_nand2_1 $PINS Y=_0511_ A=net310 B=_0490_ VDD=VDD VSS=VSS
X_1805_ sg13cmos5l_mux2_1 $PINS A0=mosi A1=\reg_out5[0] S=net290 X=_0163_
+ VDD=VDD VSS=VSS
X_1806_ sg13cmos5l_mux2_1 $PINS A0=net402 A1=\reg_out5[10] S=_0511_ X=_0164_
+ VDD=VDD VSS=VSS
X_1807_ sg13cmos5l_mux2_1 $PINS A0=net397 A1=\reg_out5[1] S=net290 X=_0165_
+ VDD=VDD VSS=VSS
X_1808_ sg13cmos5l_mux2_1 $PINS A0=net391 A1=\reg_out5[2] S=net290 X=_0166_
+ VDD=VDD VSS=VSS
X_1809_ sg13cmos5l_mux2_1 $PINS A0=net385 A1=\reg_out5[3] S=_0511_ X=_0167_
+ VDD=VDD VSS=VSS
X_1810_ sg13cmos5l_mux2_1 $PINS A0=net384 A1=\reg_out5[4] S=_0511_ X=_0168_
+ VDD=VDD VSS=VSS
X_1811_ sg13cmos5l_mux2_1 $PINS A0=net380 A1=\reg_out5[5] S=net290 X=_0169_
+ VDD=VDD VSS=VSS
X_1812_ sg13cmos5l_mux2_1 $PINS A0=net378 A1=\reg_out5[6] S=net290 X=_0170_
+ VDD=VDD VSS=VSS
X_1813_ sg13cmos5l_mux2_1 $PINS A0=net377 A1=\reg_out5[7] S=net290 X=_0171_
+ VDD=VDD VSS=VSS
X_1814_ sg13cmos5l_mux2_1 $PINS A0=net375 A1=\reg_out5[8] S=net290 X=_0172_
+ VDD=VDD VSS=VSS
X_1815_ sg13cmos5l_mux2_1 $PINS A0=net373 A1=\reg_out5[9] S=net290 X=_0173_
+ VDD=VDD VSS=VSS
X_1816_ sg13cmos5l_nand2b_1 $PINS Y=_0513_ B=net310 A_N=_0479_ VDD=VDD VSS=VSS
X_1818_ sg13cmos5l_mux2_1 $PINS A0=mosi A1=\reg_out6[0] S=net289 X=_0174_
+ VDD=VDD VSS=VSS
X_1819_ sg13cmos5l_mux2_1 $PINS A0=net402 A1=\reg_out6[10] S=_0513_ X=_0175_
+ VDD=VDD VSS=VSS
X_1820_ sg13cmos5l_mux2_1 $PINS A0=net397 A1=\reg_out6[1] S=net289 X=_0176_
+ VDD=VDD VSS=VSS
X_1821_ sg13cmos5l_mux2_1 $PINS A0=net391 A1=\reg_out6[2] S=net289 X=_0177_
+ VDD=VDD VSS=VSS
X_1822_ sg13cmos5l_mux2_1 $PINS A0=net385 A1=\reg_out6[3] S=_0513_ X=_0178_
+ VDD=VDD VSS=VSS
X_1823_ sg13cmos5l_mux2_1 $PINS A0=net384 A1=\reg_out6[4] S=_0513_ X=_0179_
+ VDD=VDD VSS=VSS
X_1824_ sg13cmos5l_mux2_1 $PINS A0=net380 A1=\reg_out6[5] S=net289 X=_0180_
+ VDD=VDD VSS=VSS
X_1825_ sg13cmos5l_mux2_1 $PINS A0=net378 A1=\reg_out6[6] S=net289 X=_0181_
+ VDD=VDD VSS=VSS
X_1826_ sg13cmos5l_mux2_1 $PINS A0=net377 A1=\reg_out6[7] S=net289 X=_0182_
+ VDD=VDD VSS=VSS
X_1827_ sg13cmos5l_mux2_1 $PINS A0=net375 A1=\reg_out6[8] S=net289 X=_0183_
+ VDD=VDD VSS=VSS
X_1828_ sg13cmos5l_mux2_1 $PINS A0=net373 A1=\reg_out6[9] S=net289 X=_0184_
+ VDD=VDD VSS=VSS
X_1829_ sg13cmos5l_nand2_1 $PINS Y=_0515_ A=net352 B=_0769_ VDD=VDD VSS=VSS
X_1830_ sg13cmos5l_o21ai_1 $PINS B1=_0515_ VDD=VDD Y=_0516_ VSS=VSS A1=net352
+ A2=_0766_
X_1831_ sg13cmos5l_nand2_1 $PINS Y=_0517_ A=_0472_ B=_0516_ VDD=VDD VSS=VSS
X_1832_ sg13cmos5l_or2_1 $PINS VSS=VSS VDD=VDD X=_0518_ B=_0517_ A=_0482_
X_1834_ sg13cmos5l_mux2_1 $PINS A0=mosi A1=\reg_out7[0] S=_0518_ X=_0185_
+ VDD=VDD VSS=VSS
X_1835_ sg13cmos5l_mux2_1 $PINS A0=net402 A1=\reg_out7[10] S=net288 X=_0186_
+ VDD=VDD VSS=VSS
X_1836_ sg13cmos5l_mux2_1 $PINS A0=net397 A1=\reg_out7[1] S=_0518_ X=_0187_
+ VDD=VDD VSS=VSS
X_1837_ sg13cmos5l_mux2_1 $PINS A0=net391 A1=\reg_out7[2] S=_0518_ X=_0188_
+ VDD=VDD VSS=VSS
X_1838_ sg13cmos5l_mux2_1 $PINS A0=net385 A1=\reg_out7[3] S=net288 X=_0189_
+ VDD=VDD VSS=VSS
X_1839_ sg13cmos5l_mux2_1 $PINS A0=net384 A1=\reg_out7[4] S=net288 X=_0190_
+ VDD=VDD VSS=VSS
X_1840_ sg13cmos5l_mux2_1 $PINS A0=net380 A1=\reg_out7[5] S=net288 X=_0191_
+ VDD=VDD VSS=VSS
X_1841_ sg13cmos5l_mux2_1 $PINS A0=net378 A1=\reg_out7[6] S=net288 X=_0192_
+ VDD=VDD VSS=VSS
X_1842_ sg13cmos5l_mux2_1 $PINS A0=net377 A1=\reg_out7[7] S=net288 X=_0193_
+ VDD=VDD VSS=VSS
X_1843_ sg13cmos5l_mux2_1 $PINS A0=net375 A1=\reg_out7[8] S=net288 X=_0194_
+ VDD=VDD VSS=VSS
X_1844_ sg13cmos5l_mux2_1 $PINS A0=net373 A1=\reg_out7[9] S=net288 X=_0195_
+ VDD=VDD VSS=VSS
X_1845_ sg13cmos5l_or2_1 $PINS VSS=VSS VDD=VDD X=_0520_ B=_0517_ A=_0497_
X_1847_ sg13cmos5l_mux2_1 $PINS A0=mosi A1=\reg_out8[0] S=_0520_ X=_0196_
+ VDD=VDD VSS=VSS
X_1848_ sg13cmos5l_mux2_1 $PINS A0=net402 A1=\reg_out8[10] S=_0520_ X=_0197_
+ VDD=VDD VSS=VSS
X_1849_ sg13cmos5l_mux2_1 $PINS A0=net397 A1=\reg_out8[1] S=_0520_ X=_0198_
+ VDD=VDD VSS=VSS
X_1850_ sg13cmos5l_mux2_1 $PINS A0=net391 A1=\reg_out8[2] S=_0520_ X=_0199_
+ VDD=VDD VSS=VSS
X_1851_ sg13cmos5l_mux2_1 $PINS A0=net385 A1=\reg_out8[3] S=net287 X=_0200_
+ VDD=VDD VSS=VSS
X_1852_ sg13cmos5l_mux2_1 $PINS A0=net384 A1=\reg_out8[4] S=net287 X=_0201_
+ VDD=VDD VSS=VSS
X_1853_ sg13cmos5l_mux2_1 $PINS A0=net380 A1=\reg_out8[5] S=net287 X=_0202_
+ VDD=VDD VSS=VSS
X_1854_ sg13cmos5l_mux2_1 $PINS A0=net378 A1=\reg_out8[6] S=net287 X=_0203_
+ VDD=VDD VSS=VSS
X_1855_ sg13cmos5l_mux2_1 $PINS A0=net377 A1=\reg_out8[7] S=net287 X=_0204_
+ VDD=VDD VSS=VSS
X_1856_ sg13cmos5l_mux2_1 $PINS A0=net375 A1=\reg_out8[8] S=net287 X=_0205_
+ VDD=VDD VSS=VSS
X_1857_ sg13cmos5l_mux2_1 $PINS A0=net373 A1=\reg_out8[9] S=net287 X=_0206_
+ VDD=VDD VSS=VSS
X_1858_ sg13cmos5l_nand2_1 $PINS Y=_0522_ A=_0730_ B=_0490_ VDD=VDD VSS=VSS
X_1860_ sg13cmos5l_mux2_1 $PINS A0=mosi A1=\reg_out9[0] S=_0522_ X=_0207_
+ VDD=VDD VSS=VSS
X_1861_ sg13cmos5l_mux2_1 $PINS A0=\bias_gen_reg_din[10] A1=\reg_out9[10]
+ S=net286 X=_0208_ VDD=VDD VSS=VSS
X_1862_ sg13cmos5l_mux2_1 $PINS A0=net399 A1=\reg_out9[1] S=_0522_ X=_0209_
+ VDD=VDD VSS=VSS
X_1863_ sg13cmos5l_mux2_1 $PINS A0=net393 A1=\reg_out9[2] S=_0522_ X=_0210_
+ VDD=VDD VSS=VSS
X_1864_ sg13cmos5l_mux2_1 $PINS A0=net386 A1=\reg_out9[3] S=net286 X=_0211_
+ VDD=VDD VSS=VSS
X_1865_ sg13cmos5l_mux2_1 $PINS A0=\bias_gen_reg_din[4] A1=\reg_out9[4]
+ S=net286 X=_0212_ VDD=VDD VSS=VSS
X_1866_ sg13cmos5l_mux2_1 $PINS A0=\bias_gen_reg_din[5] A1=\reg_out9[5]
+ S=net286 X=_0213_ VDD=VDD VSS=VSS
X_1867_ sg13cmos5l_mux2_1 $PINS A0=\bias_gen_reg_din[6] A1=\reg_out9[6]
+ S=net286 X=_0214_ VDD=VDD VSS=VSS
X_1868_ sg13cmos5l_mux2_1 $PINS A0=\bias_gen_reg_din[7] A1=\reg_out9[7]
+ S=net286 X=_0215_ VDD=VDD VSS=VSS
X_1869_ sg13cmos5l_mux2_1 $PINS A0=net374 A1=\reg_out9[8] S=net286 X=_0216_
+ VDD=VDD VSS=VSS
X_1870_ sg13cmos5l_mux2_1 $PINS A0=net372 A1=\reg_out9[9] S=net286 X=_0217_
+ VDD=VDD VSS=VSS
X_1871_ sg13cmos5l_xnor2_1 $PINS Y=_0218_ A=\u_spi_core.bit_cnt[0] B=net368
+ VDD=VDD VSS=VSS
X_1872_ sg13cmos5l_xor2_1 $PINS B=_0623_ A=\u_spi_core.bit_cnt[1] X=_0219_
+ VDD=VDD VSS=VSS
X_1873_ sg13cmos5l_nand2_1 $PINS Y=_0524_ A=\u_spi_core.bit_cnt[1] B=_0623_
+ VDD=VDD VSS=VSS
X_1874_ sg13cmos5l_xnor2_1 $PINS Y=_0220_ A=\u_spi_core.bit_cnt[2] B=_0524_
+ VDD=VDD VSS=VSS
X_1875_ sg13cmos5l_nand3_1 $PINS B=\u_spi_core.bit_cnt[2] C=_0623_
+ A=\u_spi_core.bit_cnt[1] Y=_0525_ VDD=VDD VSS=VSS
X_1876_ sg13cmos5l_xnor2_1 $PINS Y=_0221_ A=\u_spi_core.bit_cnt[3] B=_0525_
+ VDD=VDD VSS=VSS
X_1877_ sg13cmos5l_nand2_1 $PINS Y=_0526_ A=_0621_ B=_0623_ VDD=VDD VSS=VSS
X_1878_ sg13cmos5l_xnor2_1 $PINS Y=_0222_ A=\u_spi_core.bit_cnt[4] B=_0526_
+ VDD=VDD VSS=VSS
X_1879_ sg13cmos5l_a21o_1 $PINS A2=_0477_ A1=\u_spi_core.shift_in[29]
+ B1=\u_spi_core.eoc_flag X=_0223_ VDD=VDD VSS=VSS
X_1880_ sg13cmos5l_buf_1 $PINS A=clknet_1_0__leaf_sck X=_0527_ VDD=VDD VSS=VSS
X_1881__417 sg13cmos5l_inv_1 $PINS VDD=VDD Y=net416 A=clknet_1_1__leaf__0527_
+ VSS=VSS
X_1882__418 sg13cmos5l_inv_1 $PINS VDD=VDD Y=net417 A=clknet_1_0__leaf__0527_
+ VSS=VSS
X_1883__419 sg13cmos5l_inv_1 $PINS VDD=VDD Y=net418 A=clknet_1_0__leaf__0527_
+ VSS=VSS
X_1884__420 sg13cmos5l_inv_1 $PINS VDD=VDD Y=net419 A=clknet_1_1__leaf__0527_
+ VSS=VSS
X_1885__421 sg13cmos5l_inv_1 $PINS VDD=VDD Y=net420 A=clknet_1_1__leaf__0527_
+ VSS=VSS
X_1886__422 sg13cmos5l_inv_1 $PINS VDD=VDD Y=net421 A=clknet_1_1__leaf__0527_
+ VSS=VSS
X_1887__423 sg13cmos5l_inv_1 $PINS VDD=VDD Y=net422 A=clknet_1_1__leaf__0527_
+ VSS=VSS
X_1888__424 sg13cmos5l_inv_1 $PINS VDD=VDD Y=net423 A=clknet_1_0__leaf__0527_
+ VSS=VSS
X_1889__425 sg13cmos5l_inv_1 $PINS VDD=VDD Y=net424 A=clknet_1_0__leaf__0527_
+ VSS=VSS
X_1890__426 sg13cmos5l_inv_1 $PINS VDD=VDD Y=net425 A=clknet_1_0__leaf__0527_
+ VSS=VSS
X_1891__411 sg13cmos5l_inv_1 $PINS VDD=VDD Y=net410 A=clknet_leaf_8_sck_regs
+ VSS=VSS
X_1892__412 sg13cmos5l_inv_1 $PINS VDD=VDD Y=net411 A=clknet_leaf_7_sck_regs
+ VSS=VSS
X_1893__413 sg13cmos5l_inv_1 $PINS VDD=VDD Y=net412 A=clknet_leaf_8_sck_regs
+ VSS=VSS
X_1894__414 sg13cmos5l_inv_1 $PINS VDD=VDD Y=net413 A=clknet_leaf_8_sck_regs
+ VSS=VSS
X_1895__415 sg13cmos5l_inv_1 $PINS VDD=VDD Y=net414 A=clknet_leaf_8_sck_regs
+ VSS=VSS
X_1896__416 sg13cmos5l_inv_1 $PINS VDD=VDD Y=net415 A=clknet_leaf_8_sck_regs
+ VSS=VSS
X_1898_ sg13cmos5l_nand2b_1 $PINS Y=_0529_ B=\u_spi_core.read_data[0] A_N=cs_n
+ VDD=VDD VSS=VSS
X_1900_ sg13cmos5l_nand2_1 $PINS Y=_0531_ A=net370 B=\bias_gen_reg_dout[0]
+ VDD=VDD VSS=VSS
X_1901_ sg13cmos5l_o21ai_1 $PINS B1=_0531_ VDD=VDD Y=_0240_ VSS=VSS A1=net370
+ A2=_0529_
X_1902_ sg13cmos5l_nand2b_1 $PINS Y=_0532_ B=\u_spi_core.read_data[10] A_N=cs_n
+ VDD=VDD VSS=VSS
X_1903_ sg13cmos5l_nand2_1 $PINS Y=_0533_ A=net371 B=\bias_gen_reg_dout[10]
+ VDD=VDD VSS=VSS
X_1904_ sg13cmos5l_o21ai_1 $PINS B1=_0533_ VDD=VDD Y=_0241_ VSS=VSS A1=net371
+ A2=_0532_
X_1905_ sg13cmos5l_nor2_1 $PINS A=net371 B=cs_n Y=_0534_ VDD=VDD VSS=VSS
X_1906_ sg13cmos5l_and2_1 $PINS A=\u_spi_core.read_data[11] B=_0534_ X=_0242_
+ VDD=VDD VSS=VSS
X_1907_ sg13cmos5l_and2_1 $PINS A=\u_spi_core.read_data[12] B=_0534_ X=_0243_
+ VDD=VDD VSS=VSS
X_1908_ sg13cmos5l_and2_1 $PINS A=\u_spi_core.read_data[13] B=_0534_ X=_0244_
+ VDD=VDD VSS=VSS
X_1909_ sg13cmos5l_and2_1 $PINS A=\u_spi_core.read_data[14] B=_0534_ X=_0245_
+ VDD=VDD VSS=VSS
X_1910_ sg13cmos5l_and2_1 $PINS A=\u_spi_core.read_data[15] B=_0534_ X=_0246_
+ VDD=VDD VSS=VSS
X_1911_ sg13cmos5l_nand2b_1 $PINS Y=_0535_ B=\u_spi_core.read_data[1] A_N=cs_n
+ VDD=VDD VSS=VSS
X_1912_ sg13cmos5l_nand2_1 $PINS Y=_0536_ A=net370 B=\bias_gen_reg_dout[1]
+ VDD=VDD VSS=VSS
X_1913_ sg13cmos5l_o21ai_1 $PINS B1=_0536_ VDD=VDD Y=_0247_ VSS=VSS A1=net370
+ A2=_0535_
X_1914_ sg13cmos5l_nand2b_1 $PINS Y=_0537_ B=\u_spi_core.read_data[2] A_N=cs_n
+ VDD=VDD VSS=VSS
X_1915_ sg13cmos5l_nand2_1 $PINS Y=_0538_ A=net370 B=\bias_gen_reg_dout[2]
+ VDD=VDD VSS=VSS
X_1916_ sg13cmos5l_o21ai_1 $PINS B1=_0538_ VDD=VDD Y=_0248_ VSS=VSS A1=net371
+ A2=_0537_
X_1917_ sg13cmos5l_nand2b_1 $PINS Y=_0539_ B=\u_spi_core.read_data[3] A_N=cs_n
+ VDD=VDD VSS=VSS
X_1918_ sg13cmos5l_nand2_1 $PINS Y=_0540_ A=net370 B=\bias_gen_reg_dout[3]
+ VDD=VDD VSS=VSS
X_1919_ sg13cmos5l_o21ai_1 $PINS B1=_0540_ VDD=VDD Y=_0249_ VSS=VSS A1=net370
+ A2=_0539_
X_1920_ sg13cmos5l_nand2b_1 $PINS Y=_0541_ B=\u_spi_core.read_data[4] A_N=cs_n
+ VDD=VDD VSS=VSS
X_1921_ sg13cmos5l_nand2_1 $PINS Y=_0542_ A=net370 B=\bias_gen_reg_dout[4]
+ VDD=VDD VSS=VSS
X_1922_ sg13cmos5l_o21ai_1 $PINS B1=_0542_ VDD=VDD Y=_0250_ VSS=VSS A1=net371
+ A2=_0541_
X_1923_ sg13cmos5l_nand2b_1 $PINS Y=_0543_ B=\u_spi_core.read_data[5] A_N=cs_n
+ VDD=VDD VSS=VSS
X_1924_ sg13cmos5l_nand2_1 $PINS Y=_0544_ A=net371 B=\bias_gen_reg_dout[5]
+ VDD=VDD VSS=VSS
X_1925_ sg13cmos5l_o21ai_1 $PINS B1=_0544_ VDD=VDD Y=_0251_ VSS=VSS A1=net369
+ A2=_0543_
X_1926_ sg13cmos5l_nand2b_1 $PINS Y=_0545_ B=\u_spi_core.read_data[6] A_N=cs_n
+ VDD=VDD VSS=VSS
X_1927_ sg13cmos5l_nand2_1 $PINS Y=_0546_ A=\u_spi_core.bias_gen_reg_rden_d1
+ B=\bias_gen_reg_dout[6] VDD=VDD VSS=VSS
X_1928_ sg13cmos5l_o21ai_1 $PINS B1=_0546_ VDD=VDD Y=_0252_ VSS=VSS A1=net369
+ A2=_0545_
X_1929_ sg13cmos5l_nand2b_1 $PINS Y=_0547_ B=\u_spi_core.read_data[7] A_N=cs_n
+ VDD=VDD VSS=VSS
X_1930_ sg13cmos5l_nand2_1 $PINS Y=_0548_ A=net369 B=\bias_gen_reg_dout[7]
+ VDD=VDD VSS=VSS
X_1931_ sg13cmos5l_o21ai_1 $PINS B1=_0548_ VDD=VDD Y=_0253_ VSS=VSS A1=net369
+ A2=_0547_
X_1932_ sg13cmos5l_nand2b_1 $PINS Y=_0549_ B=\u_spi_core.read_data[8] A_N=cs_n
+ VDD=VDD VSS=VSS
X_1933_ sg13cmos5l_nand2_1 $PINS Y=_0550_ A=net369 B=\bias_gen_reg_dout[8]
+ VDD=VDD VSS=VSS
X_1934_ sg13cmos5l_o21ai_1 $PINS B1=_0550_ VDD=VDD Y=_0254_ VSS=VSS A1=net369
+ A2=_0549_
X_1935_ sg13cmos5l_nand2b_1 $PINS Y=_0551_ B=\u_spi_core.read_data[9] A_N=cs_n
+ VDD=VDD VSS=VSS
X_1936_ sg13cmos5l_nand2_1 $PINS Y=_0552_ A=net369 B=\bias_gen_reg_dout[9]
+ VDD=VDD VSS=VSS
X_1937_ sg13cmos5l_o21ai_1 $PINS B1=_0552_ VDD=VDD Y=_0255_ VSS=VSS A1=net369
+ A2=_0551_
X_1939_ sg13cmos5l_mux2_1 $PINS A0=\bias_gen_reg_din[15]
+ A1=\u_spi_core.shift_in[15] S=net367 X=_0256_ VDD=VDD VSS=VSS
X_1940_ sg13cmos5l_nand2_1 $PINS Y=_0554_ A=net367 B=\u_spi_core.shift_in[16]
+ VDD=VDD VSS=VSS
X_1941_ sg13cmos5l_o21ai_1 $PINS B1=_0554_ VDD=VDD Y=_0257_ VSS=VSS A1=net367
+ A2=_0616_
X_1942_ sg13cmos5l_mux2_1 $PINS A0=\u_spi_core.shift_in[16]
+ A1=\u_spi_core.shift_in[17] S=net367 X=_0258_ VDD=VDD VSS=VSS
X_1943_ sg13cmos5l_mux2_1 $PINS A0=\u_spi_core.shift_in[17] A1=net363 S=net365
+ X=_0259_ VDD=VDD VSS=VSS
X_1944_ sg13cmos5l_mux2_1 $PINS A0=net363 A1=\u_spi_core.shift_in[19] S=net368
+ X=_0260_ VDD=VDD VSS=VSS
X_1945_ sg13cmos5l_mux2_1 $PINS A0=\u_spi_core.shift_in[19]
+ A1=\u_spi_core.shift_in[20] S=net368 X=_0261_ VDD=VDD VSS=VSS
X_1946_ sg13cmos5l_mux2_1 $PINS A0=\u_spi_core.shift_in[20]
+ A1=\u_spi_core.shift_in[21] S=net366 X=_0262_ VDD=VDD VSS=VSS
X_1947_ sg13cmos5l_mux2_1 $PINS A0=\u_spi_core.shift_in[21]
+ A1=\u_spi_core.shift_in[22] S=net366 X=_0263_ VDD=VDD VSS=VSS
X_1948_ sg13cmos5l_mux2_1 $PINS A0=\u_spi_core.shift_in[22]
+ A1=\u_spi_core.shift_in[23] S=net366 X=_0264_ VDD=VDD VSS=VSS
X_1949_ sg13cmos5l_mux2_1 $PINS A0=\u_spi_core.shift_in[23]
+ A1=\u_spi_core.shift_in[24] S=net366 X=_0265_ VDD=VDD VSS=VSS
X_1950_ sg13cmos5l_mux2_1 $PINS A0=\u_spi_core.shift_in[24]
+ A1=\u_spi_core.shift_in[25] S=net366 X=_0266_ VDD=VDD VSS=VSS
X_1951_ sg13cmos5l_mux2_1 $PINS A0=\u_spi_core.shift_in[25]
+ A1=\u_spi_core.shift_in[26] S=net366 X=_0267_ VDD=VDD VSS=VSS
X_1952_ sg13cmos5l_mux2_1 $PINS A0=\u_spi_core.shift_in[26]
+ A1=\u_spi_core.shift_in[27] S=net366 X=_0268_ VDD=VDD VSS=VSS
X_1953_ sg13cmos5l_mux2_1 $PINS A0=\u_spi_core.shift_in[27]
+ A1=\u_spi_core.shift_in[28] S=net365 X=_0269_ VDD=VDD VSS=VSS
X_1954_ sg13cmos5l_mux2_1 $PINS A0=\u_spi_core.shift_in[28]
+ A1=\u_spi_core.shift_in[29] S=net365 X=_0270_ VDD=VDD VSS=VSS
X_1955_ sg13cmos5l_mux2_1 $PINS A0=\u_spi_core.shift_in[29]
+ A1=\u_spi_core.shift_in[30] S=net365 X=_0271_ VDD=VDD VSS=VSS
X\bias_gen_reg_din[10]_reg sg13cmos5l_dfrbpq_1 $PINS RESET_B=net404 VSS=VSS
+ VDD=VDD D=_0016_ Q=\bias_gen_reg_din[10] CLK=clknet_leaf_12_sck_regs
X\bias_gen_reg_din[11]_reg sg13cmos5l_dfrbpq_1 $PINS RESET_B=net404 VSS=VSS
+ VDD=VDD D=_0017_ Q=\bias_gen_reg_din[11] CLK=clknet_leaf_14_sck_regs
X\bias_gen_reg_din[12]_reg sg13cmos5l_dfrbpq_1 $PINS RESET_B=net407 VSS=VSS
+ VDD=VDD D=_0018_ Q=\bias_gen_reg_din[12] CLK=clknet_leaf_14_sck_regs
X\bias_gen_reg_din[13]_reg sg13cmos5l_dfrbpq_1 $PINS RESET_B=net403 VSS=VSS
+ VDD=VDD D=_0019_ Q=\bias_gen_reg_din[13] CLK=clknet_leaf_13_sck_regs
X\bias_gen_reg_din[14]_reg sg13cmos5l_dfrbpq_1 $PINS RESET_B=net407 VSS=VSS
+ VDD=VDD D=_0020_ Q=\bias_gen_reg_din[14] CLK=clknet_leaf_9_sck_regs
X\bias_gen_reg_din[15]_reg sg13cmos5l_dfrbpq_1 $PINS RESET_B=net407 VSS=VSS
+ VDD=VDD D=_0021_ Q=\bias_gen_reg_din[15] CLK=clknet_leaf_9_sck_regs
X\bias_gen_reg_din[1]_reg sg13cmos5l_dfrbpq_1 $PINS RESET_B=net406 VSS=VSS
+ VDD=VDD D=_0022_ Q=\bias_gen_reg_din[1] CLK=clknet_leaf_14_sck_regs
X\bias_gen_reg_din[2]_reg sg13cmos5l_dfrbpq_1 $PINS RESET_B=net406 VSS=VSS
+ VDD=VDD D=_0023_ Q=\bias_gen_reg_din[2] CLK=clknet_leaf_14_sck_regs
X\bias_gen_reg_din[3]_reg sg13cmos5l_dfrbpq_1 $PINS RESET_B=net406 VSS=VSS
+ VDD=VDD D=_0024_ Q=\bias_gen_reg_din[3] CLK=clknet_leaf_16_sck_regs
X\bias_gen_reg_din[4]_reg sg13cmos5l_dfrbpq_1 $PINS RESET_B=net406 VSS=VSS
+ VDD=VDD D=_0025_ Q=\bias_gen_reg_din[4] CLK=clknet_leaf_14_sck_regs
X\bias_gen_reg_din[5]_reg sg13cmos5l_dfrbpq_1 $PINS RESET_B=net406 VSS=VSS
+ VDD=VDD D=_0026_ Q=\bias_gen_reg_din[5] CLK=clknet_leaf_15_sck_regs
X\bias_gen_reg_din[6]_reg sg13cmos5l_dfrbpq_1 $PINS RESET_B=net406 VSS=VSS
+ VDD=VDD D=_0027_ Q=\bias_gen_reg_din[6] CLK=clknet_leaf_14_sck_regs
X\bias_gen_reg_din[7]_reg sg13cmos5l_dfrbpq_1 $PINS RESET_B=net404 VSS=VSS
+ VDD=VDD D=_0028_ Q=\bias_gen_reg_din[7] CLK=clknet_leaf_12_sck_regs
X\bias_gen_reg_din[8]_reg sg13cmos5l_dfrbpq_1 $PINS RESET_B=net404 VSS=VSS
+ VDD=VDD D=_0029_ Q=\bias_gen_reg_din[8] CLK=clknet_leaf_11_sck_regs
X\bias_gen_reg_din[9]_reg sg13cmos5l_dfrbpq_1 $PINS RESET_B=net404 VSS=VSS
+ VDD=VDD D=_0030_ Q=\bias_gen_reg_din[9] CLK=clknet_leaf_12_sck_regs
X\bias_gen_reg_dout[0]_reg sg13cmos5l_dfrbpq_1 $PINS RESET_B=rst_n VSS=VSS
+ VDD=VDD D=_0031_ Q=\bias_gen_reg_dout[0] CLK=clknet_leaf_10_sck_regs
X\bias_gen_reg_dout[10]_reg sg13cmos5l_dfrbpq_1 $PINS RESET_B=rst_n VSS=VSS
+ VDD=VDD D=_0032_ Q=\bias_gen_reg_dout[10] CLK=clknet_leaf_5_sck_regs
X\bias_gen_reg_dout[1]_reg sg13cmos5l_dfrbpq_1 $PINS RESET_B=rst_n VSS=VSS
+ VDD=VDD D=_0033_ Q=\bias_gen_reg_dout[1] CLK=clknet_leaf_5_sck_regs
X\bias_gen_reg_dout[2]_reg sg13cmos5l_dfrbpq_1 $PINS RESET_B=rst_n VSS=VSS
+ VDD=VDD D=_0034_ Q=\bias_gen_reg_dout[2] CLK=clknet_leaf_5_sck_regs
X\bias_gen_reg_dout[3]_reg sg13cmos5l_dfrbpq_1 $PINS RESET_B=rst_n VSS=VSS
+ VDD=VDD D=_0035_ Q=\bias_gen_reg_dout[3] CLK=clknet_leaf_5_sck_regs
X\bias_gen_reg_dout[4]_reg sg13cmos5l_dfrbpq_1 $PINS RESET_B=rst_n VSS=VSS
+ VDD=VDD D=_0036_ Q=\bias_gen_reg_dout[4] CLK=clknet_leaf_5_sck_regs
X\bias_gen_reg_dout[5]_reg sg13cmos5l_dfrbpq_1 $PINS RESET_B=rst_n VSS=VSS
+ VDD=VDD D=_0037_ Q=\bias_gen_reg_dout[5] CLK=clknet_leaf_7_sck_regs
X\bias_gen_reg_dout[6]_reg sg13cmos5l_dfrbpq_1 $PINS RESET_B=rst_n VSS=VSS
+ VDD=VDD D=_0038_ Q=\bias_gen_reg_dout[6] CLK=clknet_leaf_6_sck_regs
X\bias_gen_reg_dout[7]_reg sg13cmos5l_dfrbpq_1 $PINS RESET_B=rst_n VSS=VSS
+ VDD=VDD D=_0039_ Q=\bias_gen_reg_dout[7] CLK=clknet_leaf_6_sck_regs
X\bias_gen_reg_dout[8]_reg sg13cmos5l_dfrbpq_1 $PINS RESET_B=rst_n VSS=VSS
+ VDD=VDD D=_0040_ Q=\bias_gen_reg_dout[8] CLK=clknet_leaf_6_sck_regs
X\bias_gen_reg_dout[9]_reg sg13cmos5l_dfrbpq_1 $PINS RESET_B=rst_n VSS=VSS
+ VDD=VDD D=_0041_ Q=\bias_gen_reg_dout[9] CLK=clknet_leaf_5_sck_regs
Xclkbuf_0__0527_ sg13cmos5l_buf_16 $PINS X=clknet_0__0527_ A=_0527_ VDD=VDD
+ VSS=VSS
Xclkbuf_0_sck sg13cmos5l_buf_16 $PINS X=clknet_0_sck A=sck VDD=VDD VSS=VSS
Xclkbuf_0_sck_regs sg13cmos5l_buf_16 $PINS X=clknet_0_sck_regs A=sck_regs
+ VDD=VDD VSS=VSS
Xclkbuf_1_0__f__0527_ sg13cmos5l_buf_16 $PINS X=clknet_1_0__leaf__0527_
+ A=clknet_0__0527_ VDD=VDD VSS=VSS
Xclkbuf_1_0__f_sck sg13cmos5l_buf_16 $PINS X=clknet_1_0__leaf_sck
+ A=clknet_0_sck VDD=VDD VSS=VSS
Xclkbuf_1_1__f__0527_ sg13cmos5l_buf_16 $PINS X=clknet_1_1__leaf__0527_
+ A=clknet_0__0527_ VDD=VDD VSS=VSS
Xclkbuf_3_0__f_sck_regs sg13cmos5l_buf_16 $PINS X=clknet_3_0__leaf_sck_regs
+ A=clknet_0_sck_regs VDD=VDD VSS=VSS
Xclkbuf_3_1__f_sck_regs sg13cmos5l_buf_16 $PINS X=clknet_3_1__leaf_sck_regs
+ A=clknet_0_sck_regs VDD=VDD VSS=VSS
Xclkbuf_3_2__f_sck_regs sg13cmos5l_buf_16 $PINS X=clknet_3_2__leaf_sck_regs
+ A=clknet_0_sck_regs VDD=VDD VSS=VSS
Xclkbuf_3_3__f_sck_regs sg13cmos5l_buf_16 $PINS X=clknet_3_3__leaf_sck_regs
+ A=clknet_0_sck_regs VDD=VDD VSS=VSS
Xclkbuf_3_4__f_sck_regs sg13cmos5l_buf_16 $PINS X=clknet_3_4__leaf_sck_regs
+ A=clknet_0_sck_regs VDD=VDD VSS=VSS
Xclkbuf_3_5__f_sck_regs sg13cmos5l_buf_16 $PINS X=clknet_3_5__leaf_sck_regs
+ A=clknet_0_sck_regs VDD=VDD VSS=VSS
Xclkbuf_3_6__f_sck_regs sg13cmos5l_buf_16 $PINS X=clknet_3_6__leaf_sck_regs
+ A=clknet_0_sck_regs VDD=VDD VSS=VSS
Xclkbuf_3_7__f_sck_regs sg13cmos5l_buf_16 $PINS X=clknet_3_7__leaf_sck_regs
+ A=clknet_0_sck_regs VDD=VDD VSS=VSS
Xclkbuf_leaf_0_sck_regs sg13cmos5l_buf_16 $PINS X=clknet_leaf_0_sck_regs
+ A=clknet_3_0__leaf_sck_regs VDD=VDD VSS=VSS
Xclkbuf_leaf_10_sck_regs sg13cmos5l_buf_16 $PINS X=clknet_leaf_10_sck_regs
+ A=clknet_3_3__leaf_sck_regs VDD=VDD VSS=VSS
Xclkbuf_leaf_11_sck_regs sg13cmos5l_buf_16 $PINS X=clknet_leaf_11_sck_regs
+ A=clknet_3_6__leaf_sck_regs VDD=VDD VSS=VSS
Xclkbuf_leaf_12_sck_regs sg13cmos5l_buf_16 $PINS X=clknet_leaf_12_sck_regs
+ A=clknet_3_6__leaf_sck_regs VDD=VDD VSS=VSS
Xclkbuf_leaf_13_sck_regs sg13cmos5l_buf_16 $PINS X=clknet_leaf_13_sck_regs
+ A=clknet_3_6__leaf_sck_regs VDD=VDD VSS=VSS
Xclkbuf_leaf_14_sck_regs sg13cmos5l_buf_16 $PINS X=clknet_leaf_14_sck_regs
+ A=clknet_3_6__leaf_sck_regs VDD=VDD VSS=VSS
Xclkbuf_leaf_15_sck_regs sg13cmos5l_buf_16 $PINS X=clknet_leaf_15_sck_regs
+ A=clknet_3_7__leaf_sck_regs VDD=VDD VSS=VSS
Xclkbuf_leaf_16_sck_regs sg13cmos5l_buf_16 $PINS X=clknet_leaf_16_sck_regs
+ A=clknet_3_7__leaf_sck_regs VDD=VDD VSS=VSS
Xclkbuf_leaf_17_sck_regs sg13cmos5l_buf_16 $PINS X=clknet_leaf_17_sck_regs
+ A=clknet_3_7__leaf_sck_regs VDD=VDD VSS=VSS
Xclkbuf_leaf_18_sck_regs sg13cmos5l_buf_16 $PINS X=clknet_leaf_18_sck_regs
+ A=clknet_3_4__leaf_sck_regs VDD=VDD VSS=VSS
Xclkbuf_leaf_19_sck_regs sg13cmos5l_buf_16 $PINS X=clknet_leaf_19_sck_regs
+ A=clknet_3_5__leaf_sck_regs VDD=VDD VSS=VSS
Xclkbuf_leaf_1_sck_regs sg13cmos5l_buf_16 $PINS X=clknet_leaf_1_sck_regs
+ A=clknet_3_0__leaf_sck_regs VDD=VDD VSS=VSS
Xclkbuf_leaf_20_sck_regs sg13cmos5l_buf_16 $PINS X=clknet_leaf_20_sck_regs
+ A=clknet_3_5__leaf_sck_regs VDD=VDD VSS=VSS
Xclkbuf_leaf_21_sck_regs sg13cmos5l_buf_16 $PINS X=clknet_leaf_21_sck_regs
+ A=clknet_3_5__leaf_sck_regs VDD=VDD VSS=VSS
Xclkbuf_leaf_22_sck_regs sg13cmos5l_buf_16 $PINS X=clknet_leaf_22_sck_regs
+ A=clknet_3_5__leaf_sck_regs VDD=VDD VSS=VSS
Xclkbuf_leaf_23_sck_regs sg13cmos5l_buf_16 $PINS X=clknet_leaf_23_sck_regs
+ A=clknet_3_4__leaf_sck_regs VDD=VDD VSS=VSS
Xclkbuf_leaf_24_sck_regs sg13cmos5l_buf_16 $PINS X=clknet_leaf_24_sck_regs
+ A=clknet_3_4__leaf_sck_regs VDD=VDD VSS=VSS
Xclkbuf_leaf_25_sck_regs sg13cmos5l_buf_16 $PINS X=clknet_leaf_25_sck_regs
+ A=clknet_3_4__leaf_sck_regs VDD=VDD VSS=VSS
Xclkbuf_leaf_26_sck_regs sg13cmos5l_buf_16 $PINS X=clknet_leaf_26_sck_regs
+ A=clknet_3_1__leaf_sck_regs VDD=VDD VSS=VSS
Xclkbuf_leaf_27_sck_regs sg13cmos5l_buf_16 $PINS X=clknet_leaf_27_sck_regs
+ A=clknet_3_1__leaf_sck_regs VDD=VDD VSS=VSS
Xclkbuf_leaf_28_sck_regs sg13cmos5l_buf_16 $PINS X=clknet_leaf_28_sck_regs
+ A=clknet_3_1__leaf_sck_regs VDD=VDD VSS=VSS
Xclkbuf_leaf_29_sck_regs sg13cmos5l_buf_16 $PINS X=clknet_leaf_29_sck_regs
+ A=clknet_3_1__leaf_sck_regs VDD=VDD VSS=VSS
Xclkbuf_leaf_2_sck_regs sg13cmos5l_buf_16 $PINS X=clknet_leaf_2_sck_regs
+ A=clknet_3_0__leaf_sck_regs VDD=VDD VSS=VSS
Xclkbuf_leaf_30_sck_regs sg13cmos5l_buf_16 $PINS X=clknet_leaf_30_sck_regs
+ A=clknet_3_0__leaf_sck_regs VDD=VDD VSS=VSS
Xclkbuf_leaf_3_sck_regs sg13cmos5l_buf_16 $PINS X=clknet_leaf_3_sck_regs
+ A=clknet_3_2__leaf_sck_regs VDD=VDD VSS=VSS
Xclkbuf_leaf_4_sck_regs sg13cmos5l_buf_16 $PINS X=clknet_leaf_4_sck_regs
+ A=clknet_3_3__leaf_sck_regs VDD=VDD VSS=VSS
Xclkbuf_leaf_5_sck_regs sg13cmos5l_buf_16 $PINS X=clknet_leaf_5_sck_regs
+ A=clknet_3_3__leaf_sck_regs VDD=VDD VSS=VSS
Xclkbuf_leaf_6_sck_regs sg13cmos5l_buf_16 $PINS X=clknet_leaf_6_sck_regs
+ A=clknet_3_2__leaf_sck_regs VDD=VDD VSS=VSS
Xclkbuf_leaf_7_sck_regs sg13cmos5l_buf_16 $PINS X=clknet_leaf_7_sck_regs
+ A=clknet_3_2__leaf_sck_regs VDD=VDD VSS=VSS
Xclkbuf_leaf_8_sck_regs sg13cmos5l_buf_16 $PINS X=clknet_leaf_8_sck_regs
+ A=clknet_3_2__leaf_sck_regs VDD=VDD VSS=VSS
Xclkbuf_leaf_9_sck_regs sg13cmos5l_buf_16 $PINS X=clknet_leaf_9_sck_regs
+ A=clknet_3_3__leaf_sck_regs VDD=VDD VSS=VSS
Xclkbuf_regs_0_sck sg13cmos5l_buf_16 $PINS X=sck_regs A=delaynet_0_sck VDD=VDD
+ VSS=VSS
Xclkload0 sg13cmos5l_buf_16 $PINS A=clknet_3_7__leaf_sck_regs VDD=VDD VSS=VSS
Xdelaybuf_0_sck sg13cmos5l_buf_16 $PINS X=delaynet_0_sck A=sck VDD=VDD VSS=VSS
Xplace287 sg13cmos5l_buf_1 $PINS A=_0522_ X=net286 VDD=VDD VSS=VSS
Xplace288 sg13cmos5l_buf_1 $PINS A=_0520_ X=net287 VDD=VDD VSS=VSS
Xplace289 sg13cmos5l_buf_1 $PINS A=_0518_ X=net288 VDD=VDD VSS=VSS
Xplace290 sg13cmos5l_buf_1 $PINS A=_0513_ X=net289 VDD=VDD VSS=VSS
Xplace291 sg13cmos5l_buf_1 $PINS A=_0511_ X=net290 VDD=VDD VSS=VSS
Xplace292 sg13cmos5l_buf_1 $PINS A=_0507_ X=net291 VDD=VDD VSS=VSS
Xplace293 sg13cmos5l_buf_1 $PINS A=_0505_ X=net292 VDD=VDD VSS=VSS
Xplace294 sg13cmos5l_buf_1 $PINS A=_0503_ X=net293 VDD=VDD VSS=VSS
Xplace295 sg13cmos5l_buf_1 $PINS A=_0498_ X=net294 VDD=VDD VSS=VSS
Xplace296 sg13cmos5l_buf_1 $PINS A=_0495_ X=net295 VDD=VDD VSS=VSS
Xplace297 sg13cmos5l_buf_1 $PINS A=_0493_ X=net296 VDD=VDD VSS=VSS
Xplace298 sg13cmos5l_buf_1 $PINS A=_0491_ X=net297 VDD=VDD VSS=VSS
Xplace299 sg13cmos5l_buf_1 $PINS A=_0483_ X=net298 VDD=VDD VSS=VSS
Xplace300 sg13cmos5l_buf_1 $PINS A=_0480_ X=net299 VDD=VDD VSS=VSS
Xplace301 sg13cmos5l_buf_1 $PINS A=_0509_ X=net300 VDD=VDD VSS=VSS
Xplace302 sg13cmos5l_buf_1 $PINS A=_0485_ X=net301 VDD=VDD VSS=VSS
Xplace303 sg13cmos5l_buf_1 $PINS A=_0683_ X=net302 VDD=VDD VSS=VSS
Xplace304 sg13cmos5l_buf_1 $PINS A=_0677_ X=net303 VDD=VDD VSS=VSS
Xplace305 sg13cmos5l_buf_1 $PINS A=_0816_ X=net304 VDD=VDD VSS=VSS
Xplace306 sg13cmos5l_buf_1 $PINS A=_0813_ X=net305 VDD=VDD VSS=VSS
Xplace307 sg13cmos5l_buf_1 $PINS A=_0798_ X=net306 VDD=VDD VSS=VSS
Xplace308 sg13cmos5l_buf_1 $PINS A=_0776_ X=net307 VDD=VDD VSS=VSS
Xplace309 sg13cmos5l_buf_1 $PINS A=_0771_ X=net308 VDD=VDD VSS=VSS
Xplace310 sg13cmos5l_buf_1 $PINS A=net310 X=net309 VDD=VDD VSS=VSS
Xplace311 sg13cmos5l_buf_1 $PINS A=_0771_ X=net310 VDD=VDD VSS=VSS
Xplace312 sg13cmos5l_buf_1 $PINS A=_0745_ X=net311 VDD=VDD VSS=VSS
Xplace313 sg13cmos5l_buf_1 $PINS A=_0732_ X=net312 VDD=VDD VSS=VSS
Xplace314 sg13cmos5l_buf_1 $PINS A=_0714_ X=net313 VDD=VDD VSS=VSS
Xplace315 sg13cmos5l_buf_1 $PINS A=_0699_ X=net314 VDD=VDD VSS=VSS
Xplace316 sg13cmos5l_buf_1 $PINS A=_0689_ X=net315 VDD=VDD VSS=VSS
Xplace317 sg13cmos5l_buf_1 $PINS A=_0673_ X=net316 VDD=VDD VSS=VSS
Xplace318 sg13cmos5l_buf_1 $PINS A=_0629_ X=net317 VDD=VDD VSS=VSS
Xplace319 sg13cmos5l_buf_1 $PINS A=_0793_ X=net318 VDD=VDD VSS=VSS
Xplace320 sg13cmos5l_buf_1 $PINS A=_0791_ X=net319 VDD=VDD VSS=VSS
Xplace321 sg13cmos5l_buf_1 $PINS A=_0788_ X=net320 VDD=VDD VSS=VSS
Xplace322 sg13cmos5l_buf_1 $PINS A=_0782_ X=net321 VDD=VDD VSS=VSS
Xplace323 sg13cmos5l_buf_1 $PINS A=net323 X=net322 VDD=VDD VSS=VSS
Xplace324 sg13cmos5l_buf_1 $PINS A=_0782_ X=net323 VDD=VDD VSS=VSS
Xplace325 sg13cmos5l_buf_1 $PINS A=net325 X=net324 VDD=VDD VSS=VSS
Xplace326 sg13cmos5l_buf_1 $PINS A=_0780_ X=net325 VDD=VDD VSS=VSS
Xplace327 sg13cmos5l_buf_1 $PINS A=_0780_ X=net326 VDD=VDD VSS=VSS
Xplace328 sg13cmos5l_buf_1 $PINS A=_0735_ X=net327 VDD=VDD VSS=VSS
Xplace329 sg13cmos5l_buf_1 $PINS A=net329 X=net328 VDD=VDD VSS=VSS
Xplace330 sg13cmos5l_buf_1 $PINS A=_0735_ X=net329 VDD=VDD VSS=VSS
Xplace331 sg13cmos5l_buf_1 $PINS A=net332 X=net330 VDD=VDD VSS=VSS
Xplace332 sg13cmos5l_buf_1 $PINS A=net332 X=net331 VDD=VDD VSS=VSS
Xplace333 sg13cmos5l_buf_1 $PINS A=_0730_ X=net332 VDD=VDD VSS=VSS
Xplace334 sg13cmos5l_buf_1 $PINS A=_0721_ X=net333 VDD=VDD VSS=VSS
Xplace335 sg13cmos5l_buf_1 $PINS A=_0701_ X=net334 VDD=VDD VSS=VSS
Xplace336 sg13cmos5l_buf_1 $PINS A=net336 X=net335 VDD=VDD VSS=VSS
Xplace337 sg13cmos5l_buf_1 $PINS A=_0701_ X=net336 VDD=VDD VSS=VSS
Xplace338 sg13cmos5l_buf_1 $PINS A=net339 X=net337 VDD=VDD VSS=VSS
Xplace339 sg13cmos5l_buf_1 $PINS A=net339 X=net338 VDD=VDD VSS=VSS
Xplace340 sg13cmos5l_buf_1 $PINS A=_0628_ X=net339 VDD=VDD VSS=VSS
Xplace341 sg13cmos5l_buf_1 $PINS A=net341 X=net340 VDD=VDD VSS=VSS
Xplace342 sg13cmos5l_buf_1 $PINS A=net342 X=net341 VDD=VDD VSS=VSS
Xplace343 sg13cmos5l_buf_1 $PINS A=net343 X=net342 VDD=VDD VSS=VSS
Xplace344 sg13cmos5l_buf_1 $PINS A=_0568_ X=net343 VDD=VDD VSS=VSS
Xplace345 sg13cmos5l_buf_1 $PINS A=_0670_ X=net344 VDD=VDD VSS=VSS
Xplace346 sg13cmos5l_buf_1 $PINS A=net347 X=net345 VDD=VDD VSS=VSS
Xplace347 sg13cmos5l_buf_1 $PINS A=net347 X=net346 VDD=VDD VSS=VSS
Xplace348 sg13cmos5l_buf_1 $PINS A=net348 X=net347 VDD=VDD VSS=VSS
Xplace349 sg13cmos5l_buf_1 $PINS A=_0670_ X=net348 VDD=VDD VSS=VSS
Xplace350 sg13cmos5l_buf_1 $PINS A=net350 X=net349 VDD=VDD VSS=VSS
Xplace351 sg13cmos5l_buf_1 $PINS A=_0670_ X=net350 VDD=VDD VSS=VSS
Xplace352 sg13cmos5l_buf_1 $PINS A=_0661_ X=net351 VDD=VDD VSS=VSS
Xplace353 sg13cmos5l_buf_1 $PINS A=_0661_ X=net352 VDD=VDD VSS=VSS
Xplace354 sg13cmos5l_buf_1 $PINS A=net354 X=net353 VDD=VDD VSS=VSS
Xplace355 sg13cmos5l_buf_1 $PINS A=_0563_ X=net354 VDD=VDD VSS=VSS
Xplace356 sg13cmos5l_buf_1 $PINS A=_0561_ X=net355 VDD=VDD VSS=VSS
Xplace357 sg13cmos5l_buf_1 $PINS A=_0558_ X=net356 VDD=VDD VSS=VSS
Xplace358 sg13cmos5l_buf_1 $PINS A=_0733_ X=net357 VDD=VDD VSS=VSS
Xplace359 sg13cmos5l_buf_1 $PINS A=\u_spi_core.shift_in[19] X=net358 VDD=VDD
+ VSS=VSS
Xplace360 sg13cmos5l_buf_1 $PINS A=net360 X=net359 VDD=VDD VSS=VSS
Xplace361 sg13cmos5l_buf_1 $PINS A=\u_spi_core.shift_in[19] X=net360 VDD=VDD
+ VSS=VSS
Xplace362 sg13cmos5l_buf_1 $PINS A=net362 X=net361 VDD=VDD VSS=VSS
Xplace363 sg13cmos5l_buf_1 $PINS A=net363 X=net362 VDD=VDD VSS=VSS
Xplace364 sg13cmos5l_buf_1 $PINS A=\u_spi_core.shift_in[18] X=net363 VDD=VDD
+ VSS=VSS
Xplace365 sg13cmos5l_buf_1 $PINS A=net365 X=net364 VDD=VDD VSS=VSS
Xplace366 sg13cmos5l_buf_1 $PINS A=net368 X=net365 VDD=VDD VSS=VSS
Xplace367 sg13cmos5l_buf_1 $PINS A=net368 X=net366 VDD=VDD VSS=VSS
Xplace368 sg13cmos5l_buf_1 $PINS A=net368 X=net367 VDD=VDD VSS=VSS
Xplace369 sg13cmos5l_buf_1 $PINS A=\u_spi_core.bit_cnt[5] X=net368 VDD=VDD
+ VSS=VSS
Xplace370 sg13cmos5l_buf_1 $PINS A=\u_spi_core.bias_gen_reg_rden_d1 X=net369
+ VDD=VDD VSS=VSS
Xplace371 sg13cmos5l_buf_1 $PINS A=net371 X=net370 VDD=VDD VSS=VSS
Xplace372 sg13cmos5l_buf_1 $PINS A=\u_spi_core.bias_gen_reg_rden_d1 X=net371
+ VDD=VDD VSS=VSS
Xplace373 sg13cmos5l_buf_1 $PINS A=\bias_gen_reg_din[9] X=net372 VDD=VDD
+ VSS=VSS
Xplace374 sg13cmos5l_buf_1 $PINS A=\bias_gen_reg_din[9] X=net373 VDD=VDD
+ VSS=VSS
Xplace375 sg13cmos5l_buf_1 $PINS A=\bias_gen_reg_din[8] X=net374 VDD=VDD
+ VSS=VSS
Xplace376 sg13cmos5l_buf_1 $PINS A=\bias_gen_reg_din[8] X=net375 VDD=VDD
+ VSS=VSS
Xplace377 sg13cmos5l_buf_1 $PINS A=\bias_gen_reg_din[7] X=net376 VDD=VDD
+ VSS=VSS
Xplace378 sg13cmos5l_buf_1 $PINS A=\bias_gen_reg_din[7] X=net377 VDD=VDD
+ VSS=VSS
Xplace379 sg13cmos5l_buf_1 $PINS A=net379 X=net378 VDD=VDD VSS=VSS
Xplace380 sg13cmos5l_buf_1 $PINS A=\bias_gen_reg_din[6] X=net379 VDD=VDD
+ VSS=VSS
Xplace381 sg13cmos5l_buf_1 $PINS A=net381 X=net380 VDD=VDD VSS=VSS
Xplace382 sg13cmos5l_buf_1 $PINS A=\bias_gen_reg_din[5] X=net381 VDD=VDD
+ VSS=VSS
Xplace383 sg13cmos5l_buf_1 $PINS A=net383 X=net382 VDD=VDD VSS=VSS
Xplace384 sg13cmos5l_buf_1 $PINS A=\bias_gen_reg_din[4] X=net383 VDD=VDD
+ VSS=VSS
Xplace385 sg13cmos5l_buf_1 $PINS A=\bias_gen_reg_din[4] X=net384 VDD=VDD
+ VSS=VSS
Xplace386 sg13cmos5l_buf_1 $PINS A=net386 X=net385 VDD=VDD VSS=VSS
Xplace387 sg13cmos5l_buf_1 $PINS A=\bias_gen_reg_din[3] X=net386 VDD=VDD
+ VSS=VSS
Xplace388 sg13cmos5l_buf_1 $PINS A=\bias_gen_reg_din[3] X=net387 VDD=VDD
+ VSS=VSS
Xplace389 sg13cmos5l_buf_1 $PINS A=net390 X=net388 VDD=VDD VSS=VSS
Xplace390 sg13cmos5l_buf_1 $PINS A=net390 X=net389 VDD=VDD VSS=VSS
Xplace391 sg13cmos5l_buf_1 $PINS A=\bias_gen_reg_din[2] X=net390 VDD=VDD
+ VSS=VSS
Xplace392 sg13cmos5l_buf_1 $PINS A=net392 X=net391 VDD=VDD VSS=VSS
Xplace393 sg13cmos5l_buf_1 $PINS A=net393 X=net392 VDD=VDD VSS=VSS
Xplace394 sg13cmos5l_buf_1 $PINS A=net394 X=net393 VDD=VDD VSS=VSS
Xplace395 sg13cmos5l_buf_1 $PINS A=\bias_gen_reg_din[2] X=net394 VDD=VDD
+ VSS=VSS
Xplace396 sg13cmos5l_buf_1 $PINS A=net396 X=net395 VDD=VDD VSS=VSS
Xplace397 sg13cmos5l_buf_1 $PINS A=\bias_gen_reg_din[1] X=net396 VDD=VDD
+ VSS=VSS
Xplace398 sg13cmos5l_buf_1 $PINS A=net398 X=net397 VDD=VDD VSS=VSS
Xplace399 sg13cmos5l_buf_1 $PINS A=net399 X=net398 VDD=VDD VSS=VSS
Xplace400 sg13cmos5l_buf_1 $PINS A=net400 X=net399 VDD=VDD VSS=VSS
Xplace401 sg13cmos5l_buf_1 $PINS A=\bias_gen_reg_din[1] X=net400 VDD=VDD
+ VSS=VSS
Xplace402 sg13cmos5l_buf_1 $PINS A=\bias_gen_reg_din[10] X=net401 VDD=VDD
+ VSS=VSS
Xplace403 sg13cmos5l_buf_1 $PINS A=\bias_gen_reg_din[10] X=net402 VDD=VDD
+ VSS=VSS
Xplace404 sg13cmos5l_buf_1 $PINS A=net407 X=net403 VDD=VDD VSS=VSS
Xplace405 sg13cmos5l_buf_1 $PINS A=net407 X=net404 VDD=VDD VSS=VSS
Xplace406 sg13cmos5l_buf_1 $PINS A=net406 X=net405 VDD=VDD VSS=VSS
Xplace407 sg13cmos5l_buf_1 $PINS A=net407 X=net406 VDD=VDD VSS=VSS
Xplace408 sg13cmos5l_buf_1 $PINS A=net408 X=net407 VDD=VDD VSS=VSS
Xplace409 sg13cmos5l_buf_1 $PINS A=\u_spi_core.spi_rst_n X=net408 VDD=VDD
+ VSS=VSS
Xplace410 sg13cmos5l_buf_1 $PINS A=\u_spi_core.spi_rst_n X=net409 VDD=VDD
+ VSS=VSS
X\reg_out10[0]_reg sg13cmos5l_dfrbpq_1 $PINS RESET_B=rst_n VSS=VSS VDD=VDD
+ D=_0042_ Q=\reg_out10[0] CLK=clknet_leaf_24_sck_regs
X\reg_out10[10]_reg sg13cmos5l_dfrbpq_1 $PINS RESET_B=rst_n VSS=VSS VDD=VDD
+ D=_0043_ Q=\reg_out10[10] CLK=clknet_leaf_25_sck_regs
X\reg_out10[1]_reg sg13cmos5l_dfrbpq_1 $PINS RESET_B=rst_n VSS=VSS VDD=VDD
+ D=_0044_ Q=\reg_out10[1] CLK=clknet_leaf_25_sck_regs
X\reg_out10[2]_reg sg13cmos5l_dfrbpq_1 $PINS RESET_B=rst_n VSS=VSS VDD=VDD
+ D=_0045_ Q=\reg_out10[2] CLK=clknet_leaf_25_sck_regs
X\reg_out10[3]_reg sg13cmos5l_dfrbpq_1 $PINS RESET_B=rst_n VSS=VSS VDD=VDD
+ D=_0046_ Q=\reg_out10[3] CLK=clknet_leaf_25_sck_regs
X\reg_out10[4]_reg sg13cmos5l_dfrbpq_1 $PINS RESET_B=rst_n VSS=VSS VDD=VDD
+ D=_0047_ Q=\reg_out10[4] CLK=clknet_leaf_18_sck_regs
X\reg_out10[5]_reg sg13cmos5l_dfrbpq_1 $PINS RESET_B=rst_n VSS=VSS VDD=VDD
+ D=_0048_ Q=\reg_out10[5] CLK=clknet_leaf_25_sck_regs
X\reg_out10[6]_reg sg13cmos5l_dfrbpq_1 $PINS RESET_B=rst_n VSS=VSS VDD=VDD
+ D=_0049_ Q=\reg_out10[6] CLK=clknet_leaf_24_sck_regs
X\reg_out10[7]_reg sg13cmos5l_dfrbpq_1 $PINS RESET_B=rst_n VSS=VSS VDD=VDD
+ D=_0050_ Q=\reg_out10[7] CLK=clknet_leaf_25_sck_regs
X\reg_out10[8]_reg sg13cmos5l_dfrbpq_1 $PINS RESET_B=rst_n VSS=VSS VDD=VDD
+ D=_0051_ Q=\reg_out10[8] CLK=clknet_leaf_24_sck_regs
X\reg_out10[9]_reg sg13cmos5l_dfrbpq_1 $PINS RESET_B=rst_n VSS=VSS VDD=VDD
+ D=_0052_ Q=\reg_out10[9] CLK=clknet_leaf_24_sck_regs
X\reg_out11[0]_reg sg13cmos5l_dfrbpq_1 $PINS RESET_B=rst_n VSS=VSS VDD=VDD
+ D=_0053_ Q=\reg_out11[0] CLK=clknet_leaf_24_sck_regs
X\reg_out11[10]_reg sg13cmos5l_dfrbpq_1 $PINS RESET_B=rst_n VSS=VSS VDD=VDD
+ D=_0054_ Q=\reg_out11[10] CLK=clknet_leaf_17_sck_regs
X\reg_out11[1]_reg sg13cmos5l_dfrbpq_1 $PINS RESET_B=rst_n VSS=VSS VDD=VDD
+ D=_0055_ Q=\reg_out11[1] CLK=clknet_leaf_17_sck_regs
X\reg_out11[2]_reg sg13cmos5l_dfrbpq_1 $PINS RESET_B=rst_n VSS=VSS VDD=VDD
+ D=_0056_ Q=\reg_out11[2] CLK=clknet_leaf_17_sck_regs
X\reg_out11[3]_reg sg13cmos5l_dfrbpq_1 $PINS RESET_B=rst_n VSS=VSS VDD=VDD
+ D=_0057_ Q=\reg_out11[3] CLK=clknet_leaf_18_sck_regs
X\reg_out11[4]_reg sg13cmos5l_dfrbpq_1 $PINS RESET_B=rst_n VSS=VSS VDD=VDD
+ D=_0058_ Q=\reg_out11[4] CLK=clknet_leaf_18_sck_regs
X\reg_out11[5]_reg sg13cmos5l_dfrbpq_1 $PINS RESET_B=rst_n VSS=VSS VDD=VDD
+ D=_0059_ Q=\reg_out11[5] CLK=clknet_leaf_23_sck_regs
X\reg_out11[6]_reg sg13cmos5l_dfrbpq_1 $PINS RESET_B=rst_n VSS=VSS VDD=VDD
+ D=_0060_ Q=\reg_out11[6] CLK=clknet_leaf_24_sck_regs
X\reg_out11[7]_reg sg13cmos5l_dfrbpq_1 $PINS RESET_B=rst_n VSS=VSS VDD=VDD
+ D=_0061_ Q=\reg_out11[7] CLK=clknet_leaf_23_sck_regs
X\reg_out11[8]_reg sg13cmos5l_dfrbpq_1 $PINS RESET_B=rst_n VSS=VSS VDD=VDD
+ D=_0062_ Q=\reg_out11[8] CLK=clknet_leaf_24_sck_regs
X\reg_out11[9]_reg sg13cmos5l_dfrbpq_1 $PINS RESET_B=rst_n VSS=VSS VDD=VDD
+ D=_0063_ Q=\reg_out11[9] CLK=clknet_leaf_24_sck_regs
X\reg_out12[0]_reg sg13cmos5l_dfrbpq_1 $PINS RESET_B=rst_n VSS=VSS VDD=VDD
+ D=_0064_ Q=\reg_out12[0] CLK=clknet_leaf_22_sck_regs
X\reg_out12[10]_reg sg13cmos5l_dfrbpq_1 $PINS RESET_B=rst_n VSS=VSS VDD=VDD
+ D=_0065_ Q=\reg_out12[10] CLK=clknet_leaf_17_sck_regs
X\reg_out12[1]_reg sg13cmos5l_dfrbpq_1 $PINS RESET_B=rst_n VSS=VSS VDD=VDD
+ D=_0066_ Q=\reg_out12[1] CLK=clknet_leaf_23_sck_regs
X\reg_out12[2]_reg sg13cmos5l_dfrbpq_1 $PINS RESET_B=rst_n VSS=VSS VDD=VDD
+ D=_0067_ Q=\reg_out12[2] CLK=clknet_leaf_18_sck_regs
X\reg_out12[3]_reg sg13cmos5l_dfrbpq_1 $PINS RESET_B=rst_n VSS=VSS VDD=VDD
+ D=_0068_ Q=\reg_out12[3] CLK=clknet_leaf_18_sck_regs
X\reg_out12[4]_reg sg13cmos5l_dfrbpq_1 $PINS RESET_B=rst_n VSS=VSS VDD=VDD
+ D=_0069_ Q=\reg_out12[4] CLK=clknet_leaf_18_sck_regs
X\reg_out12[5]_reg sg13cmos5l_dfrbpq_1 $PINS RESET_B=rst_n VSS=VSS VDD=VDD
+ D=_0070_ Q=\reg_out12[5] CLK=clknet_leaf_23_sck_regs
X\reg_out12[6]_reg sg13cmos5l_dfrbpq_1 $PINS RESET_B=rst_n VSS=VSS VDD=VDD
+ D=_0071_ Q=\reg_out12[6] CLK=clknet_leaf_23_sck_regs
X\reg_out12[7]_reg sg13cmos5l_dfrbpq_1 $PINS RESET_B=rst_n VSS=VSS VDD=VDD
+ D=_0072_ Q=\reg_out12[7] CLK=clknet_leaf_23_sck_regs
X\reg_out12[8]_reg sg13cmos5l_dfrbpq_1 $PINS RESET_B=rst_n VSS=VSS VDD=VDD
+ D=_0073_ Q=\reg_out12[8] CLK=clknet_leaf_23_sck_regs
X\reg_out12[9]_reg sg13cmos5l_dfrbpq_1 $PINS RESET_B=rst_n VSS=VSS VDD=VDD
+ D=_0074_ Q=\reg_out12[9] CLK=clknet_leaf_23_sck_regs
X\reg_out13[0]_reg sg13cmos5l_dfrbpq_1 $PINS RESET_B=rst_n VSS=VSS VDD=VDD
+ D=_0075_ Q=\reg_out13[0] CLK=clknet_leaf_22_sck_regs
X\reg_out13[10]_reg sg13cmos5l_dfrbpq_1 $PINS RESET_B=rst_n VSS=VSS VDD=VDD
+ D=_0076_ Q=\reg_out13[10] CLK=clknet_leaf_17_sck_regs
X\reg_out13[1]_reg sg13cmos5l_dfrbpq_1 $PINS RESET_B=rst_n VSS=VSS VDD=VDD
+ D=_0077_ Q=\reg_out13[1] CLK=clknet_leaf_22_sck_regs
X\reg_out13[2]_reg sg13cmos5l_dfrbpq_1 $PINS RESET_B=rst_n VSS=VSS VDD=VDD
+ D=_0078_ Q=\reg_out13[2] CLK=clknet_leaf_18_sck_regs
X\reg_out13[3]_reg sg13cmos5l_dfrbpq_1 $PINS RESET_B=rst_n VSS=VSS VDD=VDD
+ D=_0079_ Q=\reg_out13[3] CLK=clknet_leaf_17_sck_regs
X\reg_out13[4]_reg sg13cmos5l_dfrbpq_1 $PINS RESET_B=rst_n VSS=VSS VDD=VDD
+ D=_0080_ Q=\reg_out13[4] CLK=clknet_leaf_18_sck_regs
X\reg_out13[5]_reg sg13cmos5l_dfrbpq_1 $PINS RESET_B=rst_n VSS=VSS VDD=VDD
+ D=_0081_ Q=\reg_out13[5] CLK=clknet_leaf_20_sck_regs
X\reg_out13[6]_reg sg13cmos5l_dfrbpq_1 $PINS RESET_B=rst_n VSS=VSS VDD=VDD
+ D=_0082_ Q=\reg_out13[6] CLK=clknet_leaf_22_sck_regs
X\reg_out13[7]_reg sg13cmos5l_dfrbpq_1 $PINS RESET_B=rst_n VSS=VSS VDD=VDD
+ D=_0083_ Q=\reg_out13[7] CLK=clknet_leaf_20_sck_regs
X\reg_out13[8]_reg sg13cmos5l_dfrbpq_1 $PINS RESET_B=rst_n VSS=VSS VDD=VDD
+ D=_0084_ Q=\reg_out13[8] CLK=clknet_leaf_22_sck_regs
X\reg_out13[9]_reg sg13cmos5l_dfrbpq_1 $PINS RESET_B=rst_n VSS=VSS VDD=VDD
+ D=_0085_ Q=\reg_out13[9] CLK=clknet_leaf_22_sck_regs
X\reg_out14[0]_reg sg13cmos5l_dfrbpq_1 $PINS RESET_B=rst_n VSS=VSS VDD=VDD
+ D=_0086_ Q=\reg_out14[0] CLK=clknet_leaf_21_sck_regs
X\reg_out14[10]_reg sg13cmos5l_dfrbpq_1 $PINS RESET_B=rst_n VSS=VSS VDD=VDD
+ D=_0087_ Q=\reg_out14[10] CLK=clknet_leaf_17_sck_regs
X\reg_out14[1]_reg sg13cmos5l_dfrbpq_1 $PINS RESET_B=rst_n VSS=VSS VDD=VDD
+ D=_0088_ Q=\reg_out14[1] CLK=clknet_leaf_19_sck_regs
X\reg_out14[2]_reg sg13cmos5l_dfrbpq_1 $PINS RESET_B=rst_n VSS=VSS VDD=VDD
+ D=_0089_ Q=\reg_out14[2] CLK=clknet_leaf_19_sck_regs
X\reg_out14[3]_reg sg13cmos5l_dfrbpq_1 $PINS RESET_B=rst_n VSS=VSS VDD=VDD
+ D=_0090_ Q=\reg_out14[3] CLK=clknet_leaf_17_sck_regs
X\reg_out14[4]_reg sg13cmos5l_dfrbpq_1 $PINS RESET_B=rst_n VSS=VSS VDD=VDD
+ D=_0091_ Q=\reg_out14[4] CLK=clknet_leaf_16_sck_regs
X\reg_out14[5]_reg sg13cmos5l_dfrbpq_1 $PINS RESET_B=rst_n VSS=VSS VDD=VDD
+ D=_0092_ Q=\reg_out14[5] CLK=clknet_leaf_20_sck_regs
X\reg_out14[6]_reg sg13cmos5l_dfrbpq_1 $PINS RESET_B=rst_n VSS=VSS VDD=VDD
+ D=_0093_ Q=\reg_out14[6] CLK=clknet_leaf_20_sck_regs
X\reg_out14[7]_reg sg13cmos5l_dfrbpq_1 $PINS RESET_B=rst_n VSS=VSS VDD=VDD
+ D=_0094_ Q=\reg_out14[7] CLK=clknet_leaf_19_sck_regs
X\reg_out14[8]_reg sg13cmos5l_dfrbpq_1 $PINS RESET_B=rst_n VSS=VSS VDD=VDD
+ D=_0095_ Q=\reg_out14[8] CLK=clknet_leaf_20_sck_regs
X\reg_out14[9]_reg sg13cmos5l_dfrbpq_1 $PINS RESET_B=rst_n VSS=VSS VDD=VDD
+ D=_0096_ Q=\reg_out14[9] CLK=clknet_leaf_20_sck_regs
X\reg_out15[0]_reg sg13cmos5l_dfrbpq_1 $PINS RESET_B=rst_n VSS=VSS VDD=VDD
+ D=_0097_ Q=\reg_out15[0] CLK=clknet_leaf_21_sck_regs
X\reg_out15[10]_reg sg13cmos5l_dfrbpq_1 $PINS RESET_B=rst_n VSS=VSS VDD=VDD
+ D=_0098_ Q=\reg_out15[10] CLK=clknet_leaf_16_sck_regs
X\reg_out15[1]_reg sg13cmos5l_dfrbpq_1 $PINS RESET_B=rst_n VSS=VSS VDD=VDD
+ D=_0099_ Q=\reg_out15[1] CLK=clknet_leaf_21_sck_regs
X\reg_out15[2]_reg sg13cmos5l_dfrbpq_1 $PINS RESET_B=rst_n VSS=VSS VDD=VDD
+ D=_0100_ Q=\reg_out15[2] CLK=clknet_leaf_19_sck_regs
X\reg_out15[3]_reg sg13cmos5l_dfrbpq_1 $PINS RESET_B=rst_n VSS=VSS VDD=VDD
+ D=_0101_ Q=\reg_out15[3] CLK=clknet_leaf_16_sck_regs
X\reg_out15[4]_reg sg13cmos5l_dfrbpq_1 $PINS RESET_B=rst_n VSS=VSS VDD=VDD
+ D=_0102_ Q=\reg_out15[4] CLK=clknet_leaf_16_sck_regs
X\reg_out15[5]_reg sg13cmos5l_dfrbpq_1 $PINS RESET_B=rst_n VSS=VSS VDD=VDD
+ D=_0103_ Q=\reg_out15[5] CLK=clknet_leaf_19_sck_regs
X\reg_out15[6]_reg sg13cmos5l_dfrbpq_1 $PINS RESET_B=rst_n VSS=VSS VDD=VDD
+ D=_0104_ Q=\reg_out15[6] CLK=clknet_leaf_20_sck_regs
X\reg_out15[7]_reg sg13cmos5l_dfrbpq_1 $PINS RESET_B=rst_n VSS=VSS VDD=VDD
+ D=_0105_ Q=\reg_out15[7] CLK=clknet_leaf_20_sck_regs
X\reg_out15[8]_reg sg13cmos5l_dfrbpq_1 $PINS RESET_B=rst_n VSS=VSS VDD=VDD
+ D=_0106_ Q=\reg_out15[8] CLK=clknet_leaf_22_sck_regs
X\reg_out15[9]_reg sg13cmos5l_dfrbpq_1 $PINS RESET_B=rst_n VSS=VSS VDD=VDD
+ D=_0107_ Q=\reg_out15[9] CLK=clknet_leaf_22_sck_regs
X\reg_out16[0]_reg sg13cmos5l_dfrbpq_1 $PINS RESET_B=rst_n VSS=VSS VDD=VDD
+ D=_0108_ Q=\reg_out16[0] CLK=clknet_leaf_21_sck_regs
X\reg_out16[10]_reg sg13cmos5l_dfrbpq_1 $PINS RESET_B=rst_n VSS=VSS VDD=VDD
+ D=_0109_ Q=\reg_out16[10] CLK=clknet_leaf_16_sck_regs
X\reg_out16[1]_reg sg13cmos5l_dfrbpq_1 $PINS RESET_B=rst_n VSS=VSS VDD=VDD
+ D=_0110_ Q=\reg_out16[1] CLK=clknet_leaf_21_sck_regs
X\reg_out16[2]_reg sg13cmos5l_dfrbpq_1 $PINS RESET_B=rst_n VSS=VSS VDD=VDD
+ D=_0111_ Q=\reg_out16[2] CLK=clknet_leaf_19_sck_regs
X\reg_out16[3]_reg sg13cmos5l_dfrbpq_1 $PINS RESET_B=rst_n VSS=VSS VDD=VDD
+ D=_0112_ Q=\reg_out16[3] CLK=clknet_leaf_16_sck_regs
X\reg_out16[4]_reg sg13cmos5l_dfrbpq_1 $PINS RESET_B=rst_n VSS=VSS VDD=VDD
+ D=_0113_ Q=\reg_out16[4] CLK=clknet_leaf_16_sck_regs
X\reg_out16[5]_reg sg13cmos5l_dfrbpq_1 $PINS RESET_B=rst_n VSS=VSS VDD=VDD
+ D=_0114_ Q=\reg_out16[5] CLK=clknet_leaf_19_sck_regs
X\reg_out16[6]_reg sg13cmos5l_dfrbpq_1 $PINS RESET_B=rst_n VSS=VSS VDD=VDD
+ D=_0115_ Q=\reg_out16[6] CLK=clknet_leaf_21_sck_regs
X\reg_out16[7]_reg sg13cmos5l_dfrbpq_1 $PINS RESET_B=rst_n VSS=VSS VDD=VDD
+ D=_0116_ Q=\reg_out16[7] CLK=clknet_leaf_19_sck_regs
X\reg_out16[8]_reg sg13cmos5l_dfrbpq_1 $PINS RESET_B=rst_n VSS=VSS VDD=VDD
+ D=_0117_ Q=\reg_out16[8] CLK=clknet_leaf_21_sck_regs
X\reg_out16[9]_reg sg13cmos5l_dfrbpq_1 $PINS RESET_B=rst_n VSS=VSS VDD=VDD
+ D=_0118_ Q=\reg_out16[9] CLK=clknet_leaf_21_sck_regs
X\reg_out1[0]_reg sg13cmos5l_dfrbpq_1 $PINS RESET_B=rst_n VSS=VSS VDD=VDD
+ D=_0119_ Q=\reg_out1[0] CLK=clknet_leaf_6_sck_regs
X\reg_out1[10]_reg sg13cmos5l_dfrbpq_1 $PINS RESET_B=rst_n VSS=VSS VDD=VDD
+ D=_0120_ Q=\reg_out1[10] CLK=clknet_leaf_2_sck_regs
X\reg_out1[1]_reg sg13cmos5l_dfrbpq_1 $PINS RESET_B=rst_n VSS=VSS VDD=VDD
+ D=_0121_ Q=\reg_out1[1] CLK=clknet_leaf_6_sck_regs
X\reg_out1[2]_reg sg13cmos5l_dfrbpq_1 $PINS RESET_B=rst_n VSS=VSS VDD=VDD
+ D=_0122_ Q=\reg_out1[2] CLK=clknet_leaf_6_sck_regs
X\reg_out1[3]_reg sg13cmos5l_dfrbpq_1 $PINS RESET_B=rst_n VSS=VSS VDD=VDD
+ D=_0123_ Q=\reg_out1[3] CLK=clknet_leaf_1_sck_regs
X\reg_out1[4]_reg sg13cmos5l_dfrbpq_1 $PINS RESET_B=rst_n VSS=VSS VDD=VDD
+ D=_0124_ Q=\reg_out1[4] CLK=clknet_leaf_6_sck_regs
X\reg_out1[5]_reg sg13cmos5l_dfrbpq_1 $PINS RESET_B=rst_n VSS=VSS VDD=VDD
+ D=_0125_ Q=\reg_out1[5] CLK=clknet_leaf_1_sck_regs
X\reg_out1[6]_reg sg13cmos5l_dfrbpq_1 $PINS RESET_B=rst_n VSS=VSS VDD=VDD
+ D=_0126_ Q=\reg_out1[6] CLK=clknet_leaf_2_sck_regs
X\reg_out1[7]_reg sg13cmos5l_dfrbpq_1 $PINS RESET_B=rst_n VSS=VSS VDD=VDD
+ D=_0127_ Q=\reg_out1[7] CLK=clknet_leaf_2_sck_regs
X\reg_out1[8]_reg sg13cmos5l_dfrbpq_1 $PINS RESET_B=rst_n VSS=VSS VDD=VDD
+ D=_0128_ Q=\reg_out1[8] CLK=clknet_leaf_1_sck_regs
X\reg_out1[9]_reg sg13cmos5l_dfrbpq_1 $PINS RESET_B=rst_n VSS=VSS VDD=VDD
+ D=_0129_ Q=\reg_out1[9] CLK=clknet_leaf_1_sck_regs
X\reg_out2[0]_reg sg13cmos5l_dfrbpq_1 $PINS RESET_B=rst_n VSS=VSS VDD=VDD
+ D=_0130_ Q=\reg_out2[0] CLK=clknet_leaf_30_sck_regs
X\reg_out2[10]_reg sg13cmos5l_dfrbpq_1 $PINS RESET_B=rst_n VSS=VSS VDD=VDD
+ D=_0131_ Q=\reg_out2[10] CLK=clknet_leaf_1_sck_regs
X\reg_out2[1]_reg sg13cmos5l_dfrbpq_1 $PINS RESET_B=rst_n VSS=VSS VDD=VDD
+ D=_0132_ Q=\reg_out2[1] CLK=clknet_leaf_0_sck_regs
X\reg_out2[2]_reg sg13cmos5l_dfrbpq_1 $PINS RESET_B=rst_n VSS=VSS VDD=VDD
+ D=_0133_ Q=\reg_out2[2] CLK=clknet_leaf_0_sck_regs
X\reg_out2[3]_reg sg13cmos5l_dfrbpq_1 $PINS RESET_B=rst_n VSS=VSS VDD=VDD
+ D=_0134_ Q=\reg_out2[3] CLK=clknet_leaf_1_sck_regs
X\reg_out2[4]_reg sg13cmos5l_dfrbpq_1 $PINS RESET_B=rst_n VSS=VSS VDD=VDD
+ D=_0135_ Q=\reg_out2[4] CLK=clknet_leaf_0_sck_regs
X\reg_out2[5]_reg sg13cmos5l_dfrbpq_1 $PINS RESET_B=rst_n VSS=VSS VDD=VDD
+ D=_0136_ Q=\reg_out2[5] CLK=clknet_leaf_30_sck_regs
X\reg_out2[6]_reg sg13cmos5l_dfrbpq_1 $PINS RESET_B=rst_n VSS=VSS VDD=VDD
+ D=_0137_ Q=\reg_out2[6] CLK=clknet_leaf_30_sck_regs
X\reg_out2[7]_reg sg13cmos5l_dfrbpq_1 $PINS RESET_B=rst_n VSS=VSS VDD=VDD
+ D=_0138_ Q=\reg_out2[7] CLK=clknet_leaf_30_sck_regs
X\reg_out2[8]_reg sg13cmos5l_dfrbpq_1 $PINS RESET_B=rst_n VSS=VSS VDD=VDD
+ D=_0139_ Q=\reg_out2[8] CLK=clknet_leaf_30_sck_regs
X\reg_out2[9]_reg sg13cmos5l_dfrbpq_1 $PINS RESET_B=rst_n VSS=VSS VDD=VDD
+ D=_0140_ Q=\reg_out2[9] CLK=clknet_leaf_30_sck_regs
X\reg_out3[0]_reg sg13cmos5l_dfrbpq_1 $PINS RESET_B=rst_n VSS=VSS VDD=VDD
+ D=_0141_ Q=\reg_out3[0] CLK=clknet_leaf_29_sck_regs
X\reg_out3[10]_reg sg13cmos5l_dfrbpq_1 $PINS RESET_B=rst_n VSS=VSS VDD=VDD
+ D=_0142_ Q=\reg_out3[10] CLK=clknet_leaf_1_sck_regs
X\reg_out3[1]_reg sg13cmos5l_dfrbpq_1 $PINS RESET_B=rst_n VSS=VSS VDD=VDD
+ D=_0143_ Q=\reg_out3[1] CLK=clknet_leaf_0_sck_regs
X\reg_out3[2]_reg sg13cmos5l_dfrbpq_1 $PINS RESET_B=rst_n VSS=VSS VDD=VDD
+ D=_0144_ Q=\reg_out3[2] CLK=clknet_leaf_0_sck_regs
X\reg_out3[3]_reg sg13cmos5l_dfrbpq_1 $PINS RESET_B=rst_n VSS=VSS VDD=VDD
+ D=_0145_ Q=\reg_out3[3] CLK=clknet_leaf_1_sck_regs
X\reg_out3[4]_reg sg13cmos5l_dfrbpq_1 $PINS RESET_B=rst_n VSS=VSS VDD=VDD
+ D=_0146_ Q=\reg_out3[4] CLK=clknet_leaf_0_sck_regs
X\reg_out3[5]_reg sg13cmos5l_dfrbpq_1 $PINS RESET_B=rst_n VSS=VSS VDD=VDD
+ D=_0147_ Q=\reg_out3[5] CLK=clknet_leaf_29_sck_regs
X\reg_out3[6]_reg sg13cmos5l_dfrbpq_1 $PINS RESET_B=rst_n VSS=VSS VDD=VDD
+ D=_0148_ Q=\reg_out3[6] CLK=clknet_leaf_29_sck_regs
X\reg_out3[7]_reg sg13cmos5l_dfrbpq_1 $PINS RESET_B=rst_n VSS=VSS VDD=VDD
+ D=_0149_ Q=\reg_out3[7] CLK=clknet_leaf_30_sck_regs
X\reg_out3[8]_reg sg13cmos5l_dfrbpq_1 $PINS RESET_B=rst_n VSS=VSS VDD=VDD
+ D=_0150_ Q=\reg_out3[8] CLK=clknet_leaf_29_sck_regs
X\reg_out3[9]_reg sg13cmos5l_dfrbpq_1 $PINS RESET_B=rst_n VSS=VSS VDD=VDD
+ D=_0151_ Q=\reg_out3[9] CLK=clknet_leaf_30_sck_regs
X\reg_out4[0]_reg sg13cmos5l_dfrbpq_1 $PINS RESET_B=rst_n VSS=VSS VDD=VDD
+ D=_0152_ Q=\reg_out4[0] CLK=clknet_leaf_4_sck_regs
X\reg_out4[10]_reg sg13cmos5l_dfrbpq_1 $PINS RESET_B=rst_n VSS=VSS VDD=VDD
+ D=_0153_ Q=\reg_out4[10] CLK=clknet_leaf_2_sck_regs
X\reg_out4[1]_reg sg13cmos5l_dfrbpq_1 $PINS RESET_B=rst_n VSS=VSS VDD=VDD
+ D=_0154_ Q=\reg_out4[1] CLK=clknet_leaf_5_sck_regs
X\reg_out4[2]_reg sg13cmos5l_dfrbpq_1 $PINS RESET_B=rst_n VSS=VSS VDD=VDD
+ D=_0155_ Q=\reg_out4[2] CLK=clknet_leaf_5_sck_regs
X\reg_out4[3]_reg sg13cmos5l_dfrbpq_1 $PINS RESET_B=rst_n VSS=VSS VDD=VDD
+ D=_0156_ Q=\reg_out4[3] CLK=clknet_leaf_3_sck_regs
X\reg_out4[4]_reg sg13cmos5l_dfrbpq_1 $PINS RESET_B=rst_n VSS=VSS VDD=VDD
+ D=_0157_ Q=\reg_out4[4] CLK=clknet_leaf_2_sck_regs
X\reg_out4[5]_reg sg13cmos5l_dfrbpq_1 $PINS RESET_B=rst_n VSS=VSS VDD=VDD
+ D=_0158_ Q=\reg_out4[5] CLK=clknet_leaf_2_sck_regs
X\reg_out4[6]_reg sg13cmos5l_dfrbpq_1 $PINS RESET_B=rst_n VSS=VSS VDD=VDD
+ D=_0159_ Q=\reg_out4[6] CLK=clknet_leaf_3_sck_regs
X\reg_out4[7]_reg sg13cmos5l_dfrbpq_1 $PINS RESET_B=rst_n VSS=VSS VDD=VDD
+ D=_0160_ Q=\reg_out4[7] CLK=clknet_leaf_0_sck_regs
X\reg_out4[8]_reg sg13cmos5l_dfrbpq_1 $PINS RESET_B=rst_n VSS=VSS VDD=VDD
+ D=_0161_ Q=\reg_out4[8] CLK=clknet_leaf_2_sck_regs
X\reg_out4[9]_reg sg13cmos5l_dfrbpq_1 $PINS RESET_B=rst_n VSS=VSS VDD=VDD
+ D=_0162_ Q=\reg_out4[9] CLK=clknet_leaf_2_sck_regs
X\reg_out5[0]_reg sg13cmos5l_dfrbpq_1 $PINS RESET_B=rst_n VSS=VSS VDD=VDD
+ D=_0163_ Q=\reg_out5[0] CLK=clknet_leaf_28_sck_regs
X\reg_out5[10]_reg sg13cmos5l_dfrbpq_1 $PINS RESET_B=rst_n VSS=VSS VDD=VDD
+ D=_0164_ Q=\reg_out5[10] CLK=clknet_leaf_3_sck_regs
X\reg_out5[1]_reg sg13cmos5l_dfrbpq_1 $PINS RESET_B=rst_n VSS=VSS VDD=VDD
+ D=_0165_ Q=\reg_out5[1] CLK=clknet_leaf_3_sck_regs
X\reg_out5[2]_reg sg13cmos5l_dfrbpq_1 $PINS RESET_B=rst_n VSS=VSS VDD=VDD
+ D=_0166_ Q=\reg_out5[2] CLK=clknet_leaf_29_sck_regs
X\reg_out5[3]_reg sg13cmos5l_dfrbpq_1 $PINS RESET_B=rst_n VSS=VSS VDD=VDD
+ D=_0167_ Q=\reg_out5[3] CLK=clknet_leaf_3_sck_regs
X\reg_out5[4]_reg sg13cmos5l_dfrbpq_1 $PINS RESET_B=rst_n VSS=VSS VDD=VDD
+ D=_0168_ Q=\reg_out5[4] CLK=clknet_leaf_3_sck_regs
X\reg_out5[5]_reg sg13cmos5l_dfrbpq_1 $PINS RESET_B=rst_n VSS=VSS VDD=VDD
+ D=_0169_ Q=\reg_out5[5] CLK=clknet_leaf_29_sck_regs
X\reg_out5[6]_reg sg13cmos5l_dfrbpq_1 $PINS RESET_B=rst_n VSS=VSS VDD=VDD
+ D=_0170_ Q=\reg_out5[6] CLK=clknet_leaf_28_sck_regs
X\reg_out5[7]_reg sg13cmos5l_dfrbpq_1 $PINS RESET_B=rst_n VSS=VSS VDD=VDD
+ D=_0171_ Q=\reg_out5[7] CLK=clknet_leaf_0_sck_regs
X\reg_out5[8]_reg sg13cmos5l_dfrbpq_1 $PINS RESET_B=rst_n VSS=VSS VDD=VDD
+ D=_0172_ Q=\reg_out5[8] CLK=clknet_leaf_29_sck_regs
X\reg_out5[9]_reg sg13cmos5l_dfrbpq_1 $PINS RESET_B=rst_n VSS=VSS VDD=VDD
+ D=_0173_ Q=\reg_out5[9] CLK=clknet_leaf_29_sck_regs
X\reg_out6[0]_reg sg13cmos5l_dfrbpq_1 $PINS RESET_B=rst_n VSS=VSS VDD=VDD
+ D=_0174_ Q=\reg_out6[0] CLK=clknet_leaf_28_sck_regs
X\reg_out6[10]_reg sg13cmos5l_dfrbpq_1 $PINS RESET_B=rst_n VSS=VSS VDD=VDD
+ D=_0175_ Q=\reg_out6[10] CLK=clknet_leaf_4_sck_regs
X\reg_out6[1]_reg sg13cmos5l_dfrbpq_1 $PINS RESET_B=rst_n VSS=VSS VDD=VDD
+ D=_0176_ Q=\reg_out6[1] CLK=clknet_leaf_26_sck_regs
X\reg_out6[2]_reg sg13cmos5l_dfrbpq_1 $PINS RESET_B=rst_n VSS=VSS VDD=VDD
+ D=_0177_ Q=\reg_out6[2] CLK=clknet_leaf_28_sck_regs
X\reg_out6[3]_reg sg13cmos5l_dfrbpq_1 $PINS RESET_B=rst_n VSS=VSS VDD=VDD
+ D=_0178_ Q=\reg_out6[3] CLK=clknet_leaf_3_sck_regs
X\reg_out6[4]_reg sg13cmos5l_dfrbpq_1 $PINS RESET_B=rst_n VSS=VSS VDD=VDD
+ D=_0179_ Q=\reg_out6[4] CLK=clknet_leaf_4_sck_regs
X\reg_out6[5]_reg sg13cmos5l_dfrbpq_1 $PINS RESET_B=rst_n VSS=VSS VDD=VDD
+ D=_0180_ Q=\reg_out6[5] CLK=clknet_leaf_28_sck_regs
X\reg_out6[6]_reg sg13cmos5l_dfrbpq_1 $PINS RESET_B=rst_n VSS=VSS VDD=VDD
+ D=_0181_ Q=\reg_out6[6] CLK=clknet_leaf_28_sck_regs
X\reg_out6[7]_reg sg13cmos5l_dfrbpq_1 $PINS RESET_B=rst_n VSS=VSS VDD=VDD
+ D=_0182_ Q=\reg_out6[7] CLK=clknet_leaf_3_sck_regs
X\reg_out6[8]_reg sg13cmos5l_dfrbpq_1 $PINS RESET_B=rst_n VSS=VSS VDD=VDD
+ D=_0183_ Q=\reg_out6[8] CLK=clknet_leaf_28_sck_regs
X\reg_out6[9]_reg sg13cmos5l_dfrbpq_1 $PINS RESET_B=rst_n VSS=VSS VDD=VDD
+ D=_0184_ Q=\reg_out6[9] CLK=clknet_leaf_28_sck_regs
X\reg_out7[0]_reg sg13cmos5l_dfrbpq_1 $PINS RESET_B=rst_n VSS=VSS VDD=VDD
+ D=_0185_ Q=\reg_out7[0] CLK=clknet_leaf_10_sck_regs
X\reg_out7[10]_reg sg13cmos5l_dfrbpq_1 $PINS RESET_B=rst_n VSS=VSS VDD=VDD
+ D=_0186_ Q=\reg_out7[10] CLK=clknet_leaf_4_sck_regs
X\reg_out7[1]_reg sg13cmos5l_dfrbpq_1 $PINS RESET_B=rst_n VSS=VSS VDD=VDD
+ D=_0187_ Q=\reg_out7[1] CLK=clknet_leaf_4_sck_regs
X\reg_out7[2]_reg sg13cmos5l_dfrbpq_1 $PINS RESET_B=rst_n VSS=VSS VDD=VDD
+ D=_0188_ Q=\reg_out7[2] CLK=clknet_leaf_4_sck_regs
X\reg_out7[3]_reg sg13cmos5l_dfrbpq_1 $PINS RESET_B=rst_n VSS=VSS VDD=VDD
+ D=_0189_ Q=\reg_out7[3] CLK=clknet_leaf_26_sck_regs
X\reg_out7[4]_reg sg13cmos5l_dfrbpq_1 $PINS RESET_B=rst_n VSS=VSS VDD=VDD
+ D=_0190_ Q=\reg_out7[4] CLK=clknet_leaf_26_sck_regs
X\reg_out7[5]_reg sg13cmos5l_dfrbpq_1 $PINS RESET_B=rst_n VSS=VSS VDD=VDD
+ D=_0191_ Q=\reg_out7[5] CLK=clknet_leaf_26_sck_regs
X\reg_out7[6]_reg sg13cmos5l_dfrbpq_1 $PINS RESET_B=rst_n VSS=VSS VDD=VDD
+ D=_0192_ Q=\reg_out7[6] CLK=clknet_leaf_27_sck_regs
X\reg_out7[7]_reg sg13cmos5l_dfrbpq_1 $PINS RESET_B=rst_n VSS=VSS VDD=VDD
+ D=_0193_ Q=\reg_out7[7] CLK=clknet_leaf_26_sck_regs
X\reg_out7[8]_reg sg13cmos5l_dfrbpq_1 $PINS RESET_B=rst_n VSS=VSS VDD=VDD
+ D=_0194_ Q=\reg_out7[8] CLK=clknet_leaf_27_sck_regs
X\reg_out7[9]_reg sg13cmos5l_dfrbpq_1 $PINS RESET_B=rst_n VSS=VSS VDD=VDD
+ D=_0195_ Q=\reg_out7[9] CLK=clknet_leaf_27_sck_regs
X\reg_out8[0]_reg sg13cmos5l_dfrbpq_1 $PINS RESET_B=rst_n VSS=VSS VDD=VDD
+ D=_0196_ Q=\reg_out8[0] CLK=clknet_leaf_10_sck_regs
X\reg_out8[10]_reg sg13cmos5l_dfrbpq_1 $PINS RESET_B=rst_n VSS=VSS VDD=VDD
+ D=_0197_ Q=\reg_out8[10] CLK=clknet_leaf_4_sck_regs
X\reg_out8[1]_reg sg13cmos5l_dfrbpq_1 $PINS RESET_B=rst_n VSS=VSS VDD=VDD
+ D=_0198_ Q=\reg_out8[1] CLK=clknet_leaf_4_sck_regs
X\reg_out8[2]_reg sg13cmos5l_dfrbpq_1 $PINS RESET_B=rst_n VSS=VSS VDD=VDD
+ D=_0199_ Q=\reg_out8[2] CLK=clknet_leaf_10_sck_regs
X\reg_out8[3]_reg sg13cmos5l_dfrbpq_1 $PINS RESET_B=rst_n VSS=VSS VDD=VDD
+ D=_0200_ Q=\reg_out8[3] CLK=clknet_leaf_26_sck_regs
X\reg_out8[4]_reg sg13cmos5l_dfrbpq_1 $PINS RESET_B=rst_n VSS=VSS VDD=VDD
+ D=_0201_ Q=\reg_out8[4] CLK=clknet_leaf_26_sck_regs
X\reg_out8[5]_reg sg13cmos5l_dfrbpq_1 $PINS RESET_B=rst_n VSS=VSS VDD=VDD
+ D=_0202_ Q=\reg_out8[5] CLK=clknet_leaf_27_sck_regs
X\reg_out8[6]_reg sg13cmos5l_dfrbpq_1 $PINS RESET_B=rst_n VSS=VSS VDD=VDD
+ D=_0203_ Q=\reg_out8[6] CLK=clknet_leaf_27_sck_regs
X\reg_out8[7]_reg sg13cmos5l_dfrbpq_1 $PINS RESET_B=rst_n VSS=VSS VDD=VDD
+ D=_0204_ Q=\reg_out8[7] CLK=clknet_leaf_27_sck_regs
X\reg_out8[8]_reg sg13cmos5l_dfrbpq_1 $PINS RESET_B=rst_n VSS=VSS VDD=VDD
+ D=_0205_ Q=\reg_out8[8] CLK=clknet_leaf_27_sck_regs
X\reg_out8[9]_reg sg13cmos5l_dfrbpq_1 $PINS RESET_B=rst_n VSS=VSS VDD=VDD
+ D=_0206_ Q=\reg_out8[9] CLK=clknet_leaf_27_sck_regs
X\reg_out9[0]_reg sg13cmos5l_dfrbpq_1 $PINS RESET_B=rst_n VSS=VSS VDD=VDD
+ D=_0207_ Q=\reg_out9[0] CLK=clknet_leaf_25_sck_regs
X\reg_out9[10]_reg sg13cmos5l_dfrbpq_1 $PINS RESET_B=rst_n VSS=VSS VDD=VDD
+ D=_0208_ Q=\reg_out9[10] CLK=clknet_leaf_10_sck_regs
X\reg_out9[1]_reg sg13cmos5l_dfrbpq_1 $PINS RESET_B=rst_n VSS=VSS VDD=VDD
+ D=_0209_ Q=\reg_out9[1] CLK=clknet_leaf_25_sck_regs
X\reg_out9[2]_reg sg13cmos5l_dfrbpq_1 $PINS RESET_B=rst_n VSS=VSS VDD=VDD
+ D=_0210_ Q=\reg_out9[2] CLK=clknet_leaf_26_sck_regs
X\reg_out9[3]_reg sg13cmos5l_dfrbpq_1 $PINS RESET_B=rst_n VSS=VSS VDD=VDD
+ D=_0211_ Q=\reg_out9[3] CLK=clknet_leaf_11_sck_regs
X\reg_out9[4]_reg sg13cmos5l_dfrbpq_1 $PINS RESET_B=rst_n VSS=VSS VDD=VDD
+ D=_0212_ Q=\reg_out9[4] CLK=clknet_leaf_11_sck_regs
X\reg_out9[5]_reg sg13cmos5l_dfrbpq_1 $PINS RESET_B=rst_n VSS=VSS VDD=VDD
+ D=_0213_ Q=\reg_out9[5] CLK=clknet_leaf_11_sck_regs
X\reg_out9[6]_reg sg13cmos5l_dfrbpq_1 $PINS RESET_B=rst_n VSS=VSS VDD=VDD
+ D=_0214_ Q=\reg_out9[6] CLK=clknet_leaf_11_sck_regs
X\reg_out9[7]_reg sg13cmos5l_dfrbpq_1 $PINS RESET_B=rst_n VSS=VSS VDD=VDD
+ D=_0215_ Q=\reg_out9[7] CLK=clknet_leaf_11_sck_regs
X\reg_out9[8]_reg sg13cmos5l_dfrbpq_1 $PINS RESET_B=rst_n VSS=VSS VDD=VDD
+ D=_0216_ Q=\reg_out9[8] CLK=clknet_leaf_11_sck_regs
X\reg_out9[9]_reg sg13cmos5l_dfrbpq_1 $PINS RESET_B=rst_n VSS=VSS VDD=VDD
+ D=_0217_ Q=\reg_out9[9] CLK=clknet_leaf_11_sck_regs
X\u_spi_core.bias_gen_reg_rden_d1_reg sg13cmos5l_dfrbpq_1 $PINS RESET_B=net
+ VSS=VSS VDD=VDD D=_0629_ Q=\u_spi_core.bias_gen_reg_rden_d1
+ CLK=clknet_leaf_6_sck_regs
X\u_spi_core.bias_gen_reg_rden_d1_reg_1 sg13cmos5l_tiehi $PINS VDD=VDD VSS=VSS
+ L_HI=net
X\u_spi_core.bit_cnt[0]_reg sg13cmos5l_dfrbpq_1 $PINS RESET_B=net403 VSS=VSS
+ VDD=VDD D=_0218_ Q=\u_spi_core.bit_cnt[0] CLK=clknet_leaf_13_sck_regs
X\u_spi_core.bit_cnt[1]_reg sg13cmos5l_dfrbpq_1 $PINS RESET_B=net403 VSS=VSS
+ VDD=VDD D=_0219_ Q=\u_spi_core.bit_cnt[1] CLK=clknet_leaf_12_sck_regs
X\u_spi_core.bit_cnt[2]_reg sg13cmos5l_dfrbpq_1 $PINS RESET_B=net403 VSS=VSS
+ VDD=VDD D=_0220_ Q=\u_spi_core.bit_cnt[2] CLK=clknet_leaf_12_sck_regs
X\u_spi_core.bit_cnt[3]_reg sg13cmos5l_dfrbpq_1 $PINS RESET_B=net403 VSS=VSS
+ VDD=VDD D=_0221_ Q=\u_spi_core.bit_cnt[3] CLK=clknet_leaf_12_sck_regs
X\u_spi_core.bit_cnt[4]_reg sg13cmos5l_dfrbpq_1 $PINS RESET_B=net403 VSS=VSS
+ VDD=VDD D=_0222_ Q=\u_spi_core.bit_cnt[4] CLK=clknet_leaf_13_sck_regs
X\u_spi_core.bit_cnt[5]_reg sg13cmos5l_dfrbpq_1 $PINS RESET_B=net403 VSS=VSS
+ VDD=VDD D=_0272_ Q=\u_spi_core.bit_cnt[5] CLK=clknet_leaf_13_sck_regs
X\u_spi_core.eoc_flag_reg sg13cmos5l_dfrbpq_1 $PINS RESET_B=rst_n VSS=VSS
+ VDD=VDD D=_0223_ Q=\u_spi_core.eoc_flag CLK=clknet_leaf_9_sck_regs
X\u_spi_core.miso_shift[0]_reg sg13cmos5l_dfrbpq_1 $PINS RESET_B=net408 VSS=VSS
+ VDD=VDD D=_0224_ Q=\u_spi_core.miso_shift[0] CLK=net416
X\u_spi_core.miso_shift[10]_reg sg13cmos5l_dfrbpq_1 $PINS RESET_B=net409
+ VSS=VSS VDD=VDD D=_0225_ Q=\u_spi_core.miso_shift[10] CLK=net417
X\u_spi_core.miso_shift[11]_reg sg13cmos5l_dfrbpq_1 $PINS
+ RESET_B=\u_spi_core.spi_rst_n VSS=VSS VDD=VDD D=_0226_
+ Q=\u_spi_core.miso_shift[11] CLK=net418
X\u_spi_core.miso_shift[12]_reg sg13cmos5l_dfrbpq_1 $PINS
+ RESET_B=\u_spi_core.spi_rst_n VSS=VSS VDD=VDD D=_0227_
+ Q=\u_spi_core.miso_shift[12] CLK=net419
X\u_spi_core.miso_shift[13]_reg sg13cmos5l_dfrbpq_1 $PINS RESET_B=net408
+ VSS=VSS VDD=VDD D=_0228_ Q=\u_spi_core.miso_shift[13] CLK=net420
X\u_spi_core.miso_shift[14]_reg sg13cmos5l_dfrbpq_1 $PINS RESET_B=net408
+ VSS=VSS VDD=VDD D=_0229_ Q=\u_spi_core.miso_shift[14] CLK=net421
X\u_spi_core.miso_shift[15]_reg sg13cmos5l_dfrbpq_1 $PINS RESET_B=net408
+ VSS=VSS VDD=VDD D=_0230_ Q=\u_spi_core.miso_shift[15] CLK=net422
X\u_spi_core.miso_shift[1]_reg sg13cmos5l_dfrbpq_1 $PINS
+ RESET_B=\u_spi_core.spi_rst_n VSS=VSS VDD=VDD D=_0231_
+ Q=\u_spi_core.miso_shift[1] CLK=net423
X\u_spi_core.miso_shift[2]_reg sg13cmos5l_dfrbpq_1 $PINS RESET_B=net409 VSS=VSS
+ VDD=VDD D=_0232_ Q=\u_spi_core.miso_shift[2] CLK=net424
X\u_spi_core.miso_shift[3]_reg sg13cmos5l_dfrbpq_1 $PINS
+ RESET_B=\u_spi_core.spi_rst_n VSS=VSS VDD=VDD D=_0233_
+ Q=\u_spi_core.miso_shift[3] CLK=net425
X\u_spi_core.miso_shift[4]_reg sg13cmos5l_dfrbpq_1 $PINS RESET_B=net409 VSS=VSS
+ VDD=VDD D=_0234_ Q=\u_spi_core.miso_shift[4] CLK=net410
X\u_spi_core.miso_shift[5]_reg sg13cmos5l_dfrbpq_1 $PINS RESET_B=net409 VSS=VSS
+ VDD=VDD D=_0235_ Q=\u_spi_core.miso_shift[5] CLK=net411
X\u_spi_core.miso_shift[6]_reg sg13cmos5l_dfrbpq_1 $PINS RESET_B=net409 VSS=VSS
+ VDD=VDD D=_0236_ Q=\u_spi_core.miso_shift[6] CLK=net412
X\u_spi_core.miso_shift[7]_reg sg13cmos5l_dfrbpq_1 $PINS RESET_B=net409 VSS=VSS
+ VDD=VDD D=_0237_ Q=\u_spi_core.miso_shift[7] CLK=net413
X\u_spi_core.miso_shift[8]_reg sg13cmos5l_dfrbpq_1 $PINS RESET_B=net409 VSS=VSS
+ VDD=VDD D=_0238_ Q=\u_spi_core.miso_shift[8] CLK=net414
X\u_spi_core.miso_shift[9]_reg sg13cmos5l_dfrbpq_1 $PINS RESET_B=net409 VSS=VSS
+ VDD=VDD D=_0239_ Q=\u_spi_core.miso_shift[9] CLK=net415
X\u_spi_core.read_data[0]_reg sg13cmos5l_dfrbpq_1 $PINS RESET_B=rst_n VSS=VSS
+ VDD=VDD D=_0240_ Q=\u_spi_core.read_data[0] CLK=clknet_leaf_10_sck_regs
X\u_spi_core.read_data[10]_reg sg13cmos5l_dfrbpq_1 $PINS RESET_B=rst_n VSS=VSS
+ VDD=VDD D=_0241_ Q=\u_spi_core.read_data[10] CLK=clknet_leaf_7_sck_regs
X\u_spi_core.read_data[11]_reg sg13cmos5l_dfrbpq_1 $PINS RESET_B=rst_n VSS=VSS
+ VDD=VDD D=_0242_ Q=\u_spi_core.read_data[11] CLK=clknet_leaf_8_sck_regs
X\u_spi_core.read_data[12]_reg sg13cmos5l_dfrbpq_1 $PINS RESET_B=rst_n VSS=VSS
+ VDD=VDD D=_0243_ Q=\u_spi_core.read_data[12] CLK=clknet_leaf_9_sck_regs
X\u_spi_core.read_data[13]_reg sg13cmos5l_dfrbpq_1 $PINS RESET_B=rst_n VSS=VSS
+ VDD=VDD D=_0244_ Q=\u_spi_core.read_data[13] CLK=clknet_leaf_9_sck_regs
X\u_spi_core.read_data[14]_reg sg13cmos5l_dfrbpq_1 $PINS RESET_B=rst_n VSS=VSS
+ VDD=VDD D=_0245_ Q=\u_spi_core.read_data[14] CLK=clknet_leaf_9_sck_regs
X\u_spi_core.read_data[15]_reg sg13cmos5l_dfrbpq_1 $PINS RESET_B=rst_n VSS=VSS
+ VDD=VDD D=_0246_ Q=\u_spi_core.read_data[15] CLK=clknet_leaf_9_sck_regs
X\u_spi_core.read_data[1]_reg sg13cmos5l_dfrbpq_1 $PINS RESET_B=rst_n VSS=VSS
+ VDD=VDD D=_0247_ Q=\u_spi_core.read_data[1] CLK=clknet_leaf_10_sck_regs
X\u_spi_core.read_data[2]_reg sg13cmos5l_dfrbpq_1 $PINS RESET_B=rst_n VSS=VSS
+ VDD=VDD D=_0248_ Q=\u_spi_core.read_data[2] CLK=clknet_leaf_8_sck_regs
X\u_spi_core.read_data[3]_reg sg13cmos5l_dfrbpq_1 $PINS RESET_B=rst_n VSS=VSS
+ VDD=VDD D=_0249_ Q=\u_spi_core.read_data[3] CLK=clknet_leaf_10_sck_regs
X\u_spi_core.read_data[4]_reg sg13cmos5l_dfrbpq_1 $PINS RESET_B=rst_n VSS=VSS
+ VDD=VDD D=_0250_ Q=\u_spi_core.read_data[4] CLK=clknet_leaf_8_sck_regs
X\u_spi_core.read_data[5]_reg sg13cmos5l_dfrbpq_1 $PINS RESET_B=rst_n VSS=VSS
+ VDD=VDD D=_0251_ Q=\u_spi_core.read_data[5] CLK=clknet_leaf_7_sck_regs
X\u_spi_core.read_data[6]_reg sg13cmos5l_dfrbpq_1 $PINS RESET_B=rst_n VSS=VSS
+ VDD=VDD D=_0252_ Q=\u_spi_core.read_data[6] CLK=clknet_leaf_7_sck_regs
X\u_spi_core.read_data[7]_reg sg13cmos5l_dfrbpq_1 $PINS RESET_B=rst_n VSS=VSS
+ VDD=VDD D=_0253_ Q=\u_spi_core.read_data[7] CLK=clknet_leaf_7_sck_regs
X\u_spi_core.read_data[8]_reg sg13cmos5l_dfrbpq_1 $PINS RESET_B=rst_n VSS=VSS
+ VDD=VDD D=_0254_ Q=\u_spi_core.read_data[8] CLK=clknet_leaf_7_sck_regs
X\u_spi_core.read_data[9]_reg sg13cmos5l_dfrbpq_1 $PINS RESET_B=rst_n VSS=VSS
+ VDD=VDD D=_0255_ Q=\u_spi_core.read_data[9] CLK=clknet_leaf_7_sck_regs
X\u_spi_core.shift_in[15]_reg sg13cmos5l_dfrbpq_1 $PINS RESET_B=net408 VSS=VSS
+ VDD=VDD D=_0256_ Q=\u_spi_core.shift_in[15] CLK=clknet_leaf_9_sck_regs
X\u_spi_core.shift_in[16]_reg sg13cmos5l_dfrbpq_1 $PINS RESET_B=net408 VSS=VSS
+ VDD=VDD D=_0257_ Q=\u_spi_core.shift_in[16] CLK=clknet_leaf_12_sck_regs
X\u_spi_core.shift_in[17]_reg sg13cmos5l_dfrbpq_1 $PINS RESET_B=net408 VSS=VSS
+ VDD=VDD D=_0258_ Q=\u_spi_core.shift_in[17] CLK=clknet_leaf_13_sck_regs
X\u_spi_core.shift_in[18]_reg sg13cmos5l_dfrbpq_1 $PINS RESET_B=net404 VSS=VSS
+ VDD=VDD D=_0259_ Q=\u_spi_core.shift_in[18] CLK=clknet_leaf_13_sck_regs
X\u_spi_core.shift_in[19]_reg sg13cmos5l_dfrbpq_1 $PINS RESET_B=net405 VSS=VSS
+ VDD=VDD D=_0260_ Q=\u_spi_core.shift_in[19] CLK=clknet_leaf_14_sck_regs
X\u_spi_core.shift_in[20]_reg sg13cmos5l_dfrbpq_1 $PINS RESET_B=net405 VSS=VSS
+ VDD=VDD D=_0261_ Q=\u_spi_core.shift_in[20] CLK=clknet_leaf_14_sck_regs
X\u_spi_core.shift_in[21]_reg sg13cmos5l_dfrbpq_1 $PINS RESET_B=net405 VSS=VSS
+ VDD=VDD D=_0262_ Q=\u_spi_core.shift_in[21] CLK=clknet_leaf_15_sck_regs
X\u_spi_core.shift_in[22]_reg sg13cmos5l_dfrbpq_1 $PINS RESET_B=net405 VSS=VSS
+ VDD=VDD D=_0263_ Q=\u_spi_core.shift_in[22] CLK=clknet_leaf_15_sck_regs
X\u_spi_core.shift_in[23]_reg sg13cmos5l_dfrbpq_1 $PINS RESET_B=net405 VSS=VSS
+ VDD=VDD D=_0264_ Q=\u_spi_core.shift_in[23] CLK=clknet_leaf_15_sck_regs
X\u_spi_core.shift_in[24]_reg sg13cmos5l_dfrbpq_1 $PINS RESET_B=net405 VSS=VSS
+ VDD=VDD D=_0265_ Q=\u_spi_core.shift_in[24] CLK=clknet_leaf_15_sck_regs
X\u_spi_core.shift_in[25]_reg sg13cmos5l_dfrbpq_1 $PINS RESET_B=net405 VSS=VSS
+ VDD=VDD D=_0266_ Q=\u_spi_core.shift_in[25] CLK=clknet_leaf_15_sck_regs
X\u_spi_core.shift_in[26]_reg sg13cmos5l_dfrbpq_1 $PINS RESET_B=net405 VSS=VSS
+ VDD=VDD D=_0267_ Q=\u_spi_core.shift_in[26] CLK=clknet_leaf_15_sck_regs
X\u_spi_core.shift_in[27]_reg sg13cmos5l_dfrbpq_1 $PINS RESET_B=net406 VSS=VSS
+ VDD=VDD D=_0268_ Q=\u_spi_core.shift_in[27] CLK=clknet_leaf_15_sck_regs
X\u_spi_core.shift_in[28]_reg sg13cmos5l_dfrbpq_1 $PINS RESET_B=net403 VSS=VSS
+ VDD=VDD D=_0269_ Q=\u_spi_core.shift_in[28] CLK=clknet_leaf_13_sck_regs
X\u_spi_core.shift_in[29]_reg sg13cmos5l_dfrbpq_1 $PINS RESET_B=net404 VSS=VSS
+ VDD=VDD D=_0270_ Q=\u_spi_core.shift_in[29] CLK=clknet_leaf_13_sck_regs
X\u_spi_core.shift_in[30]_reg sg13cmos5l_dfrbpq_1 $PINS RESET_B=net404 VSS=VSS
+ VDD=VDD D=_0271_ Q=\u_spi_core.shift_in[30] CLK=clknet_leaf_12_sck_regs
.ENDS

* expanding   symbol:  INI_Block_analog.sym # of pins=33
** sym_path: /foss/designs/ihp_INI_project/INI_Block/INI_Block_analog.sym
** sch_path: /foss/designs/ihp_INI_project/INI_Block/INI_Block_analog.sch
.subckt INI_Block_analog BIASGEN_en_VS[10] BIASGEN_en_VS[9] BIASGEN_en_VS[8] BIASGEN_en_VS[7] BIASGEN_en_VS[6] BIASGEN_en_VS[5]
+ BIASGEN_en_VS[4] BIASGEN_en_VS[3] BIASGEN_en_VS[2] BIASGEN_en_VS[1] BIASGEN_en_VS[0] BIASGEN_BYP_en_VS[10] BIASGEN_BYP_en_VS[9]
+ BIASGEN_BYP_en_VS[8] BIASGEN_BYP_en_VS[7] BIASGEN_BYP_en_VS[6] BIASGEN_BYP_en_VS[5] BIASGEN_BYP_en_VS[4] BIASGEN_BYP_en_VS[3] BIASGEN_BYP_en_VS[2]
+ BIASGEN_BYP_en_VS[1] BIASGEN_BYP_en_VS[0] BIASGEN_EXT_REF_en_VS[10] BIASGEN_EXT_REF_en_VS[9] BIASGEN_EXT_REF_en_VS[8] BIASGEN_EXT_REF_en_VS[7]
+ BIASGEN_EXT_REF_en_VS[6] BIASGEN_EXT_REF_en_VS[5] BIASGEN_EXT_REF_en_VS[4] BIASGEN_EXT_REF_en_VS[3] BIASGEN_EXT_REF_en_VS[2] BIASGEN_EXT_REF_en_VS[1]
+ BIASGEN_EXT_REF_en_VS[0] reg_out7[10] reg_out7[9] reg_out7[8] reg_out7[7] reg_out7[6] reg_out7[5] reg_out7[4] reg_out7[3] reg_out7[2] reg_out7[1]
+ reg_out7[0] reg_out9[10] reg_out9[9] reg_out9[8] reg_out9[7] reg_out9[6] reg_out9[5] reg_out9[4] reg_out9[3] reg_out9[2] reg_out9[1]
+ reg_out9[0] reg_out1[10] reg_out1[9] reg_out1[8] reg_out1[7] reg_out1[6] reg_out1[5] reg_out1[4] reg_out1[3] reg_out1[2] reg_out1[1]
+ reg_out1[0] reg_out6[10] reg_out6[9] reg_out6[8] reg_out6[7] reg_out6[6] reg_out6[5] reg_out6[4] reg_out6[3] reg_out6[2] reg_out6[1]
+ reg_out6[0] reg_out5[10] reg_out5[9] reg_out5[8] reg_out5[7] reg_out5[6] reg_out5[5] reg_out5[4] reg_out5[3] reg_out5[2] reg_out5[1]
+ reg_out5[0] reg_out3[10] reg_out3[9] reg_out3[8] reg_out3[7] reg_out3[6] reg_out3[5] reg_out3[4] reg_out3[3] reg_out3[2] reg_out3[1]
+ reg_out3[0] reg_out8[10] reg_out8[9] reg_out8[8] reg_out8[7] reg_out8[6] reg_out8[5] reg_out8[4] reg_out8[3] reg_out8[2] reg_out8[1]
+ reg_out8[0] reg_out2[10] reg_out2[9] reg_out2[8] reg_out2[7] reg_out2[6] reg_out2[5] reg_out2[4] reg_out2[3] reg_out2[2] reg_out2[1]
+ reg_out2[0] reg_out4[10] reg_out4[9] reg_out4[8] reg_out4[7] reg_out4[6] reg_out4[5] reg_out4[4] reg_out4[3] reg_out4[2] reg_out4[1]
+ reg_out4[0] BG_PROB NN3_MEM_PROB NN3_REQ NN3_ACK NN2_MEM_PROB NN2_REQ NN2_ACK VDD NN1_MEM_PROB V2I_INP NN1_REQ V2I_INN BG_100kRES NN1_ACK VSS
+ BG_BIAS BG_100mV C2F_REQ C2F_ACK C2F_COMP MEM_bufferbias
*.PININFO VSS:I VDD:I NN1_REQ:O NN1_ACK:I V2I_INN:I V2I_INP:I reg_out9[10:0]:I BG_PROB:O reg_out8[10:0]:I reg_out7[10:0]:I
*+ reg_out6[10:0]:I reg_out5[10:0]:I reg_out4[10:0]:I reg_out3[10:0]:I reg_out2[10:0]:I reg_out1[10:0]:I BG_100mV:I BG_BIAS:I BG_100kRES:I NN2_REQ:O
*+ NN2_ACK:I NN3_REQ:O NN3_ACK:I BIASGEN_en_VS[10:0]:I BIASGEN_BYP_en_VS[10:0]:I BIASGEN_EXT_REF_en_VS[10:0]:I C2F_REQ:O C2F_COMP:O C2F_ACK:I
*+ MEM_bufferbias:I NN1_MEM_PROB:O NN2_MEM_PROB:O NN3_MEM_PROB:O
x15 VDD NNDPI_gain_VNI NNDPI_lk_VNI net1 NN1_REQ NNADAP_gain_VPI NNADAPDPI_gain_VNI NN1_ADAP_cap_VTO NN1_ACK NNADAPDPI_lk_VNI
+ NNREF_lk_VNI VSS NN1_REF_cap_VTO NNPULEXT_pwbias_VPI net2 neuron_LVS
x16 VDD V2I_imax_VPI V2I_INN V2I_INP net2 VSS V2I
* noconn C2F_REQ
* noconn C2F_COMP
x17 reg_out9[10] reg_out9[9] reg_out9[8] reg_out9[7] reg_out9[6] reg_out9[5] reg_out9[4] reg_out9[3] reg_out9[2] reg_out9[1]
+ reg_out9[0] VSS VDD net7 BG_PROB ref_VUN[7] ref_VUN[6] ref_VUN[5] ref_VUN[4] ref_VUN[3] ref_VUN[2] ref_VUN[1] ref_VUN[0] BIASGEN_en_VS[0]
+ CoreFineDAC_CurrentOutput_N
* noconn #net7
x1 ref_VUN[7] ref_VUN[6] ref_VUN[5] ref_VUN[4] ref_VUN[3] ref_VUN[2] ref_VUN[1] ref_VUN[0] VSS BIASGEN_en_VS[0] CoreDiodeT
x2 reg_out8[10] reg_out8[9] reg_out8[8] reg_out8[7] reg_out8[6] reg_out8[5] reg_out8[4] reg_out8[3] reg_out8[2] reg_out8[1]
+ reg_out8[0] VSS VDD NNPULEXT_pwbias_VPI net8 ref_VUN[7] ref_VUN[6] ref_VUN[5] ref_VUN[4] ref_VUN[3] ref_VUN[2] ref_VUN[1] ref_VUN[0]
+ BIASGEN_en_VS[0] CoreFineDAC_N
* noconn #net8
x10 reg_out7[10] reg_out7[9] reg_out7[8] reg_out7[7] reg_out7[6] reg_out7[5] reg_out7[4] reg_out7[3] reg_out7[2] reg_out7[1]
+ reg_out7[0] VSS VDD net9 NNADAPDPI_lk_VNI ref_VUN[7] ref_VUN[6] ref_VUN[5] ref_VUN[4] ref_VUN[3] ref_VUN[2] ref_VUN[1] ref_VUN[0]
+ BIASGEN_en_VS[0] CoreFineDAC_N
* noconn #net9
x9 reg_out6[10] reg_out6[9] reg_out6[8] reg_out6[7] reg_out6[6] reg_out6[5] reg_out6[4] reg_out6[3] reg_out6[2] reg_out6[1]
+ reg_out6[0] VSS VDD net10 NNADAPDPI_gain_VNI ref_VUN[7] ref_VUN[6] ref_VUN[5] ref_VUN[4] ref_VUN[3] ref_VUN[2] ref_VUN[1] ref_VUN[0]
+ BIASGEN_en_VS[0] CoreFineDAC_N
* noconn #net10
x8 reg_out5[10] reg_out5[9] reg_out5[8] reg_out5[7] reg_out5[6] reg_out5[5] reg_out5[4] reg_out5[3] reg_out5[2] reg_out5[1]
+ reg_out5[0] VSS VDD NNADAP_gain_VPI net11 ref_VUN[7] ref_VUN[6] ref_VUN[5] ref_VUN[4] ref_VUN[3] ref_VUN[2] ref_VUN[1] ref_VUN[0]
+ BIASGEN_en_VS[0] CoreFineDAC_N
* noconn #net11
x7 reg_out4[10] reg_out4[9] reg_out4[8] reg_out4[7] reg_out4[6] reg_out4[5] reg_out4[4] reg_out4[3] reg_out4[2] reg_out4[1]
+ reg_out4[0] VSS VDD net12 NNREF_lk_VNI ref_VUN[7] ref_VUN[6] ref_VUN[5] ref_VUN[4] ref_VUN[3] ref_VUN[2] ref_VUN[1] ref_VUN[0]
+ BIASGEN_en_VS[0] CoreFineDAC_N
* noconn #net12
x4 reg_out3[10] reg_out3[9] reg_out3[8] reg_out3[7] reg_out3[6] reg_out3[5] reg_out3[4] reg_out3[3] reg_out3[2] reg_out3[1]
+ reg_out3[0] VSS VDD net13 NNDPI_lk_VNI ref_VUN[7] ref_VUN[6] ref_VUN[5] ref_VUN[4] ref_VUN[3] ref_VUN[2] ref_VUN[1] ref_VUN[0]
+ BIASGEN_en_VS[0] CoreFineDAC_N
* noconn #net13
x6 reg_out2[10] reg_out2[9] reg_out2[8] reg_out2[7] reg_out2[6] reg_out2[5] reg_out2[4] reg_out2[3] reg_out2[2] reg_out2[1]
+ reg_out2[0] VSS VDD net14 NNDPI_gain_VNI ref_VUN[7] ref_VUN[6] ref_VUN[5] ref_VUN[4] ref_VUN[3] ref_VUN[2] ref_VUN[1] ref_VUN[0]
+ BIASGEN_en_VS[0] CoreFineDAC_N
* noconn #net14
x12 reg_out1[10] reg_out1[9] reg_out1[8] reg_out1[7] reg_out1[6] reg_out1[5] reg_out1[4] reg_out1[3] reg_out1[2] reg_out1[1]
+ reg_out1[0] VSS VDD V2I_imax_VPI net15 ref_VUN[7] ref_VUN[6] ref_VUN[5] ref_VUN[4] ref_VUN[3] ref_VUN[2] ref_VUN[1] ref_VUN[0]
+ BIASGEN_en_VS[0] CoreFineDAC_N
* noconn #net15
x14 VDD V2I_imax_VPI V2I_INN V2I_INP net5 VSS V2I
x3 VDD V2I_imax_VPI V2I_INN V2I_INP net4 VSS V2I
x5 BG_BIAS BIASGEN_BYP_en_VS[0] BG_100mV BIASGEN_EXT_REF_en_VS[0] VDD ref_VUN[7] ref_VUN[6] ref_VUN[5] ref_VUN[4] ref_VUN[3]
+ ref_VUN[2] ref_VUN[1] ref_VUN[0] BG_100kRES VSS MasterBias
x11 VDD NNDPI_gain_VNI NNDPI_lk_VNI net6 NN2_REQ NNADAP_gain_VPI NNADAPDPI_gain_VNI NN2_ADAP_cap_VTO NN2_ACK NNADAPDPI_lk_VNI
+ NNREF_lk_VNI VSS NN2_REF_cap_VTO NNPULEXT_pwbias_VPI net5 neuron_LVS
x13 VDD NNDPI_gain_VNI NNDPI_lk_VNI net3 NN3_REQ NNADAP_gain_VPI NNADAPDPI_gain_VNI NN3_ADAP_cap_VTO NN3_ACK NNADAPDPI_lk_VNI
+ NNREF_lk_VNI VSS NN3_REF_cap_VTO NNPULEXT_pwbias_VPI net4 neuron_LVS
* noconn C2F_ACK
x18 VDD NN1_MEM_PROB net1 NN1_MEM_PROB MEM_bufferbias VSS a_buffP
x19 VDD NN2_MEM_PROB net6 NN2_MEM_PROB MEM_bufferbias VSS a_buffP
x20 VDD NN3_MEM_PROB net3 NN3_MEM_PROB MEM_bufferbias VSS a_buffP
* noconn BIASGEN_en_VS[10:1]
* noconn BIASGEN_EXT_REF_en_VS[10:1]
* noconn BIASGEN_BYP_en_VS[10:1]
.ends

* expanding   symbol:  neuron_LVS.sym # of pins=15
** sym_path: /foss/designs/ihp_INI_project/INI_Block/neuron_LVS.sym
** sch_path: /foss/designs/ihp_INI_project/INI_Block/neuron_LVS.sch
.subckt neuron_LVS vdda DPI_gain_VNI DPI_lk_VNI SOM_mem_VTO req_VAO ADAP_gain_VPI ADAPDPI_gain_VNI ADAPDPI_cap_VTO ack_VAI
+ ADAPDPI_lk_VNI REF_lk_VNI vssa REF_cap_VTO PULEXT_pwbias_VPI DPI_in_UNI
*.PININFO REF_lk_VNI:I vssa:B vdda:B req_VAO:O ack_VAI:I DPI_lk_VNI:I ADAP_gain_VPI:I ADAPDPI_gain_VNI:I ADAPDPI_lk_VNI:I
*+ ADAPDPI_cap_VTO:O SOM_mem_VTO:O REF_cap_VTO:O PULEXT_pwbias_VPI:I DPI_gain_VNI:I DPI_in_UNI:B
Xfb vdda FB_cmpstate_VABO SOM_mem_VTO vssa FB_system
Xadap vdda PULEXT_ackext_VABO ADAPDPI_cap_VTO ADAP_gain_VPI DPI_in_UNI ADAPDPI_gain_VNI ADAPDPI_lk_VNI vssa ADAP_system
Xref net2 SOM_mem_VTO net1 REF_cap_VTO vssa REF_lk_VNI vdda REF_system
xext vdda vssa net3 ack_VAI PULEXT_pwbias_VPI PULEXT_cap_VP pulse_extender_V2
Xinv2 vdda net1 req_VAO vssa inv
Xinv3 vdda net2 ack_VAI vssa inv
Xinv4 vdda PULEXT_ackext_VABO net3 vssa inv
x1 vdda req_VAO FB_cmpstate_VABO vssa inv_hc
Xdpi1 DPI_in_UNI vdda SOM_mem_VTO DPI_gain_VNI vssa DPI_lk_VNI DPI_gain
x2 SOM_mem_VTO vssa cfringe60x8
x3 ADAPDPI_cap_VTO vssa cfringe35x8
x4 REF_cap_VTO vssa cfringe35x8
x5 PULEXT_cap_VP vssa cfringe6x3
.ends

* expanding   symbol:  V2I.sym # of pins=6
** sym_path: /foss/designs/ihp_INI_project/INI_Block/V2I.sym
** sch_path: /foss/designs/ihp_INI_project/INI_Block/V2I.sch
.subckt V2I vdda imax_VPI inputcm_VNI inputcm_VPI out_UPO vssa
*.PININFO inputcm_VNI:I inputcm_VPI:I out_UPO:O imax_VPI:I vdda:B vssa:B
MMIRA Vm Vm vssa vssa sg13_hv_nmos w=4u l=1u ng=2 m=4
MMBIAS Vb imax_VPI vdda vdda sg13_hv_pmos w=4u l=1u ng=2 m=4
MMIRB out_UPO Vm vssa vssa sg13_hv_nmos w=4u l=1u ng=2 m=4
MMdiffINN out_UPO inputcm_VNI Vb vdda sg13_hv_pmos w=4u l=1u ng=2 m=4
MMIDC out_UPO imax_VPI vdda vdda sg13_hv_pmos w=3u l=1u ng=2 m=4
MMdiffINP Vm inputcm_VPI Vb vdda sg13_hv_pmos w=4u l=1u ng=2 m=4
MMDdiffINP Vb Vb Vb vdda sg13_hv_pmos w=4u l=1u ng=2 m=2
MMDdiffINN Vb Vb Vb vdda sg13_hv_pmos w=4u l=1u ng=2 m=2
.ends

* expanding   symbol:  CoreFineDAC_CurrentOutput_N.sym # of pins=7
** sym_path: /foss/designs/ihp_INI_project/INI_Block/CoreFineDAC_CurrentOutput_N.sym
** sch_path: /foss/designs/ihp_INI_project/INI_Block/CoreFineDAC_CurrentOutput_N.sch
.subckt CoreFineDAC_CurrentOutput_N en_VS[10] en_VS[9] en_VS[8] en_VS[7] en_VS[6] en_VS[5] en_VS[4] en_VS[3] en_VS[2] en_VS[1]
+ en_VS[0] vssa vdda bias_VP bias_VN MASTER_CoreDiodeT_bias_VN[7] MASTER_CoreDiodeT_bias_VN[6] MASTER_CoreDiodeT_bias_VN[5]
+ MASTER_CoreDiodeT_bias_VN[4] MASTER_CoreDiodeT_bias_VN[3] MASTER_CoreDiodeT_bias_VN[2] MASTER_CoreDiodeT_bias_VN[1] MASTER_CoreDiodeT_bias_VN[0] BIASGEN_en_VS
*.PININFO MASTER_CoreDiodeT_bias_VN[7:0]:I en_VS[10:0]:I vssa:B vdda:B bias_VP:B bias_VN:B BIASGEN_en_VS:I
xinv[10] vdda en_VSB[10] en_VS[10] vssa inv_BG
xinv[9] vdda en_VSB[9] en_VS[9] vssa inv_BG
xinv[8] vdda en_VSB[8] en_VS[8] vssa inv_BG
xinv[7] vdda en_VSB[7] en_VS[7] vssa inv_BG
xinv[6] vdda en_VSB[6] en_VS[6] vssa inv_BG
xinv[5] vdda en_VSB[5] en_VS[5] vssa inv_BG
xinv[4] vdda en_VSB[4] en_VS[4] vssa inv_BG
xinv[3] vdda en_VSB[3] en_VS[3] vssa inv_BG
xinv[2] vdda en_VSB[2] en_VS[2] vssa inv_BG
xinv[1] vdda en_VSB[1] en_VS[1] vssa inv_BG
xinv[0] vdda en_VSB[0] en_VS[0] vssa inv_BG
x1 MASTER_CoreDiodeT_bias_VN[7] MASTER_CoreDiodeT_bias_VN[6] MASTER_CoreDiodeT_bias_VN[5] MASTER_CoreDiodeT_bias_VN[4]
+ MASTER_CoreDiodeT_bias_VN[3] MASTER_CoreDiodeT_bias_VN[2] MASTER_CoreDiodeT_bias_VN[1] MASTER_CoreDiodeT_bias_VN[0] vssa en_VS[10] en_VS[9] en_VS[8]
+ en_VSB[10] en_VSB[9] en_VSB[8] MASTER_biasout_VN SelMUX
xisink0[2] MASTER_biasout_VN vssa BIASGEN_en_VS net1 vssa ISINK
xisink0[1] MASTER_biasout_VN vssa BIASGEN_en_VS net1 vssa ISINK
MM1 net1 net1 vdda vdda sg13_hv_pmos w=2u l=1u ng=1 m=2
MM2 bias_test net1 vdda vdda sg13_hv_pmos w=2u l=1u ng=1 m=2
x4 en_VS[0] net8 net2 en_VSB[0] bias_test vssa vdda bias_VP SplitterCell
MM_enb vdda vdda net3 vssa sg13_hv_nmos w=1u l=1u ng=1
MM_s9 net2 bias_test net9 vssa sg13_hv_nmos w=2u l=10u ng=1
MM_s10 net9 bias_test net10 vssa sg13_hv_nmos w=2u l=10u ng=1
MM_s11 net10 bias_test net11 vssa sg13_hv_nmos w=2u l=10u ng=1
MM_s12 net11 bias_test net3 vssa sg13_hv_nmos w=2u l=10u ng=1
x5 en_VS[1] net12 net8 en_VSB[1] bias_test vssa vdda bias_VP SplitterCell
x6 en_VS[2] net13 net12 en_VSB[2] bias_test vssa vdda bias_VP SplitterCell
x7 en_VS[3] net14 net13 en_VSB[3] bias_test vssa vdda bias_VP SplitterCell
x8 en_VS[4] net15 net14 en_VSB[4] bias_test vssa vdda bias_VP SplitterCell
x9 en_VS[5] net16 net15 en_VSB[5] bias_test vssa vdda bias_VP SplitterCell
x10 en_VS[6] net17 net16 en_VSB[6] bias_test vssa vdda bias_VP SplitterCell
x11 en_VS[7] V_drain_ISINK net17 en_VSB[7] bias_test vssa vdda bias_VP SplitterCell
MM8 net4 bias_VP vdda vdda sg13_hv_pmos w=4u l=1u ng=1 m=2
MM7 net5 bias_VP vdda vdda sg13_hv_pmos w=4u l=1u ng=1 m=2
MM9 bias_VP MASTER_CoreDiodeT_bias_VN[2] net4 vdda sg13_hv_pmos w=4u l=0.5u ng=1 m=2
MM10 bias_VN MASTER_CoreDiodeT_bias_VN[2] net5 vdda sg13_hv_pmos w=4u l=0.5u ng=1 m=2
xisink2[2] net6 vssa BIASGEN_en_VS net6 vssa ISINK
xisink2[1] net6 vssa BIASGEN_en_VS net6 vssa ISINK
MM_b4 bias_test bias_test net7 vssa sg13_hv_nmos w=2u l=6u ng=1
xisink1[8] MASTER_biasout_VN vssa BIASGEN_en_VS V_drain_ISINK vssa ISINK
xisink1[7] MASTER_biasout_VN vssa BIASGEN_en_VS V_drain_ISINK vssa ISINK
xisink1[6] MASTER_biasout_VN vssa BIASGEN_en_VS V_drain_ISINK vssa ISINK
xisink1[5] MASTER_biasout_VN vssa BIASGEN_en_VS V_drain_ISINK vssa ISINK
xisink1[4] MASTER_biasout_VN vssa BIASGEN_en_VS V_drain_ISINK vssa ISINK
xisink1[3] MASTER_biasout_VN vssa BIASGEN_en_VS V_drain_ISINK vssa ISINK
xisink1[2] MASTER_biasout_VN vssa BIASGEN_en_VS V_drain_ISINK vssa ISINK
xisink1[1] MASTER_biasout_VN vssa BIASGEN_en_VS V_drain_ISINK vssa ISINK
MM_b3 net7 net7 vssa vssa sg13_hv_nmos w=2u l=6u ng=1
x3 bias_VP vdda cfringe34x70
x2 net6 vssa cfringe33x55
MM3 vdda vdda bias_VP vdda sg13_hv_pmos w=4u l=0.45u ng=1 m=2
MM4 vdda vdda bias_VN vdda sg13_hv_pmos w=4u l=0.45u ng=1 m=2
.ends

* expanding   symbol:  CoreDiodeT.sym # of pins=3
** sym_path: /foss/designs/ihp_INI_project/INI_Block/CoreDiodeT.sym
** sch_path: /foss/designs/ihp_INI_project/INI_Block/CoreDiodeT.sch
.subckt CoreDiodeT ref_VUN[7] ref_VUN[6] ref_VUN[5] ref_VUN[4] ref_VUN[3] ref_VUN[2] ref_VUN[1] ref_VUN[0] vssa en_VS
*.PININFO ref_VUN[7:0]:B en_VS:I vssa:B
x2[8] ref_VUN[7] vssa en_VS ref_VUN[7] vssa ISINK
x2[7] ref_VUN[7] vssa en_VS ref_VUN[7] vssa ISINK
x2[6] ref_VUN[7] vssa en_VS ref_VUN[7] vssa ISINK
x2[5] ref_VUN[7] vssa en_VS ref_VUN[7] vssa ISINK
x2[4] ref_VUN[7] vssa en_VS ref_VUN[7] vssa ISINK
x2[3] ref_VUN[7] vssa en_VS ref_VUN[7] vssa ISINK
x2[2] ref_VUN[7] vssa en_VS ref_VUN[7] vssa ISINK
x2[1] ref_VUN[7] vssa en_VS ref_VUN[7] vssa ISINK
x9[8] ref_VUN[6] vssa en_VS ref_VUN[6] vssa ISINK
x9[7] ref_VUN[6] vssa en_VS ref_VUN[6] vssa ISINK
x9[6] ref_VUN[6] vssa en_VS ref_VUN[6] vssa ISINK
x9[5] ref_VUN[6] vssa en_VS ref_VUN[6] vssa ISINK
x9[4] ref_VUN[6] vssa en_VS ref_VUN[6] vssa ISINK
x9[3] ref_VUN[6] vssa en_VS ref_VUN[6] vssa ISINK
x9[2] ref_VUN[6] vssa en_VS ref_VUN[6] vssa ISINK
x9[1] ref_VUN[6] vssa en_VS ref_VUN[6] vssa ISINK
x10[8] ref_VUN[5] vssa en_VS ref_VUN[5] vssa ISINK
x10[7] ref_VUN[5] vssa en_VS ref_VUN[5] vssa ISINK
x10[6] ref_VUN[5] vssa en_VS ref_VUN[5] vssa ISINK
x10[5] ref_VUN[5] vssa en_VS ref_VUN[5] vssa ISINK
x10[4] ref_VUN[5] vssa en_VS ref_VUN[5] vssa ISINK
x10[3] ref_VUN[5] vssa en_VS ref_VUN[5] vssa ISINK
x10[2] ref_VUN[5] vssa en_VS ref_VUN[5] vssa ISINK
x10[1] ref_VUN[5] vssa en_VS ref_VUN[5] vssa ISINK
x11[8] ref_VUN[4] vssa en_VS ref_VUN[4] vssa ISINK
x11[7] ref_VUN[4] vssa en_VS ref_VUN[4] vssa ISINK
x11[6] ref_VUN[4] vssa en_VS ref_VUN[4] vssa ISINK
x11[5] ref_VUN[4] vssa en_VS ref_VUN[4] vssa ISINK
x11[4] ref_VUN[4] vssa en_VS ref_VUN[4] vssa ISINK
x11[3] ref_VUN[4] vssa en_VS ref_VUN[4] vssa ISINK
x11[2] ref_VUN[4] vssa en_VS ref_VUN[4] vssa ISINK
x11[1] ref_VUN[4] vssa en_VS ref_VUN[4] vssa ISINK
x12[8] ref_VUN[3] vssa en_VS ref_VUN[3] vssa ISINK
x12[7] ref_VUN[3] vssa en_VS ref_VUN[3] vssa ISINK
x12[6] ref_VUN[3] vssa en_VS ref_VUN[3] vssa ISINK
x12[5] ref_VUN[3] vssa en_VS ref_VUN[3] vssa ISINK
x12[4] ref_VUN[3] vssa en_VS ref_VUN[3] vssa ISINK
x12[3] ref_VUN[3] vssa en_VS ref_VUN[3] vssa ISINK
x12[2] ref_VUN[3] vssa en_VS ref_VUN[3] vssa ISINK
x12[1] ref_VUN[3] vssa en_VS ref_VUN[3] vssa ISINK
x13[8] ref_VUN[2] vssa en_VS ref_VUN[2] vssa ISINK
x13[7] ref_VUN[2] vssa en_VS ref_VUN[2] vssa ISINK
x13[6] ref_VUN[2] vssa en_VS ref_VUN[2] vssa ISINK
x13[5] ref_VUN[2] vssa en_VS ref_VUN[2] vssa ISINK
x13[4] ref_VUN[2] vssa en_VS ref_VUN[2] vssa ISINK
x13[3] ref_VUN[2] vssa en_VS ref_VUN[2] vssa ISINK
x13[2] ref_VUN[2] vssa en_VS ref_VUN[2] vssa ISINK
x13[1] ref_VUN[2] vssa en_VS ref_VUN[2] vssa ISINK
x14[8] ref_VUN[1] vssa en_VS ref_VUN[1] vssa ISINK
x14[7] ref_VUN[1] vssa en_VS ref_VUN[1] vssa ISINK
x14[6] ref_VUN[1] vssa en_VS ref_VUN[1] vssa ISINK
x14[5] ref_VUN[1] vssa en_VS ref_VUN[1] vssa ISINK
x14[4] ref_VUN[1] vssa en_VS ref_VUN[1] vssa ISINK
x14[3] ref_VUN[1] vssa en_VS ref_VUN[1] vssa ISINK
x14[2] ref_VUN[1] vssa en_VS ref_VUN[1] vssa ISINK
x14[1] ref_VUN[1] vssa en_VS ref_VUN[1] vssa ISINK
x8[8] ref_VUN[0] vssa en_VS ref_VUN[0] vssa ISINK
x8[7] ref_VUN[0] vssa en_VS ref_VUN[0] vssa ISINK
x8[6] ref_VUN[0] vssa en_VS ref_VUN[0] vssa ISINK
x8[5] ref_VUN[0] vssa en_VS ref_VUN[0] vssa ISINK
x8[4] ref_VUN[0] vssa en_VS ref_VUN[0] vssa ISINK
x8[3] ref_VUN[0] vssa en_VS ref_VUN[0] vssa ISINK
x8[2] ref_VUN[0] vssa en_VS ref_VUN[0] vssa ISINK
x8[1] ref_VUN[0] vssa en_VS ref_VUN[0] vssa ISINK
x1 vssa ref_VUN[7] cfringe140x6
x2 vssa ref_VUN[6] cfringe140x6
x3 vssa ref_VUN[5] cfringe140x6
x4 vssa ref_VUN[4] cfringe140x6
x5 vssa ref_VUN[3] cfringe140x6
x6 vssa ref_VUN[2] cfringe140x6
x7 vssa ref_VUN[1] cfringe140x6
x8 vssa ref_VUN[0] cfringe140x6
.ends

* expanding   symbol:  CoreFineDAC_N.sym # of pins=7
** sym_path: /foss/designs/ihp_INI_project/INI_Block/CoreFineDAC_N.sym
** sch_path: /foss/designs/ihp_INI_project/INI_Block/CoreFineDAC_N.sch
.subckt CoreFineDAC_N en_VS[10] en_VS[9] en_VS[8] en_VS[7] en_VS[6] en_VS[5] en_VS[4] en_VS[3] en_VS[2] en_VS[1] en_VS[0] vssa
+ vdda bias_VP bias_VN MASTER_CoreDiodeT_bias_VN[7] MASTER_CoreDiodeT_bias_VN[6] MASTER_CoreDiodeT_bias_VN[5]
+ MASTER_CoreDiodeT_bias_VN[4] MASTER_CoreDiodeT_bias_VN[3] MASTER_CoreDiodeT_bias_VN[2] MASTER_CoreDiodeT_bias_VN[1] MASTER_CoreDiodeT_bias_VN[0] BIASGEN_en_VS
*.PININFO MASTER_CoreDiodeT_bias_VN[7:0]:I en_VS[10:0]:I vssa:B vdda:B bias_VP:B bias_VN:B BIASGEN_en_VS:I
xinv[10] vdda en_VSB[10] en_VS[10] vssa inv_BG
xinv[9] vdda en_VSB[9] en_VS[9] vssa inv_BG
xinv[8] vdda en_VSB[8] en_VS[8] vssa inv_BG
xinv[7] vdda en_VSB[7] en_VS[7] vssa inv_BG
xinv[6] vdda en_VSB[6] en_VS[6] vssa inv_BG
xinv[5] vdda en_VSB[5] en_VS[5] vssa inv_BG
xinv[4] vdda en_VSB[4] en_VS[4] vssa inv_BG
xinv[3] vdda en_VSB[3] en_VS[3] vssa inv_BG
xinv[2] vdda en_VSB[2] en_VS[2] vssa inv_BG
xinv[1] vdda en_VSB[1] en_VS[1] vssa inv_BG
xinv[0] vdda en_VSB[0] en_VS[0] vssa inv_BG
x1 MASTER_CoreDiodeT_bias_VN[7] MASTER_CoreDiodeT_bias_VN[6] MASTER_CoreDiodeT_bias_VN[5] MASTER_CoreDiodeT_bias_VN[4]
+ MASTER_CoreDiodeT_bias_VN[3] MASTER_CoreDiodeT_bias_VN[2] MASTER_CoreDiodeT_bias_VN[1] MASTER_CoreDiodeT_bias_VN[0] vssa en_VS[10] en_VS[9] en_VS[8]
+ en_VSB[10] en_VSB[9] en_VSB[8] MASTER_biasout_VN SelMUX
xisink0[2] MASTER_biasout_VN vssa BIASGEN_en_VS net1 vssa ISINK
xisink0[1] MASTER_biasout_VN vssa BIASGEN_en_VS net1 vssa ISINK
MM1 net1 net1 vdda vdda sg13_hv_pmos w=2u l=1u ng=1 m=2
MM2 bias_test net1 vdda vdda sg13_hv_pmos w=2u l=1u ng=1 m=2
x4 en_VS[0] net7 net2 en_VSB[0] bias_test vssa vdda bias_VP SplitterCell
MM_enb vdda vdda net3 vssa sg13_hv_nmos w=1u l=1u ng=1
MM_s9 net2 bias_test net8 vssa sg13_hv_nmos w=2u l=10u ng=1
MM_s10 net8 bias_test net9 vssa sg13_hv_nmos w=2u l=10u ng=1
MM_s11 net9 bias_test net10 vssa sg13_hv_nmos w=2u l=10u ng=1
MM_s12 net10 bias_test net3 vssa sg13_hv_nmos w=2u l=10u ng=1
x5 en_VS[1] net11 net7 en_VSB[1] bias_test vssa vdda bias_VP SplitterCell
x6 en_VS[2] net12 net11 en_VSB[2] bias_test vssa vdda bias_VP SplitterCell
x7 en_VS[3] net13 net12 en_VSB[3] bias_test vssa vdda bias_VP SplitterCell
x8 en_VS[4] net14 net13 en_VSB[4] bias_test vssa vdda bias_VP SplitterCell
x9 en_VS[5] net15 net14 en_VSB[5] bias_test vssa vdda bias_VP SplitterCell
x10 en_VS[6] net16 net15 en_VSB[6] bias_test vssa vdda bias_VP SplitterCell
x11 en_VS[7] V_drain_ISINK net16 en_VSB[7] bias_test vssa vdda bias_VP SplitterCell
MM8 net4 bias_VP vdda vdda sg13_hv_pmos w=4u l=1u ng=1 m=2
MM7 net5 bias_VP vdda vdda sg13_hv_pmos w=4u l=1u ng=1 m=2
MM9 bias_VP MASTER_CoreDiodeT_bias_VN[2] net4 vdda sg13_hv_pmos w=4u l=0.5u ng=1 m=2
MM10 bias_VN MASTER_CoreDiodeT_bias_VN[2] net5 vdda sg13_hv_pmos w=4u l=0.5u ng=1 m=2
xisink2[2] bias_VN vssa BIASGEN_en_VS bias_VN vssa ISINK
xisink2[1] bias_VN vssa BIASGEN_en_VS bias_VN vssa ISINK
MM_b4 bias_test bias_test net6 vssa sg13_hv_nmos w=2u l=6u ng=1
xisink1[8] MASTER_biasout_VN vssa BIASGEN_en_VS V_drain_ISINK vssa ISINK
xisink1[7] MASTER_biasout_VN vssa BIASGEN_en_VS V_drain_ISINK vssa ISINK
xisink1[6] MASTER_biasout_VN vssa BIASGEN_en_VS V_drain_ISINK vssa ISINK
xisink1[5] MASTER_biasout_VN vssa BIASGEN_en_VS V_drain_ISINK vssa ISINK
xisink1[4] MASTER_biasout_VN vssa BIASGEN_en_VS V_drain_ISINK vssa ISINK
xisink1[3] MASTER_biasout_VN vssa BIASGEN_en_VS V_drain_ISINK vssa ISINK
xisink1[2] MASTER_biasout_VN vssa BIASGEN_en_VS V_drain_ISINK vssa ISINK
xisink1[1] MASTER_biasout_VN vssa BIASGEN_en_VS V_drain_ISINK vssa ISINK
MM_b3 net6 net6 vssa vssa sg13_hv_nmos w=2u l=6u ng=1
MM3 vdda vdda bias_VP vdda sg13_hv_pmos w=4u l=0.45u ng=1 m=2
MM4 vdda vdda bias_VN vdda sg13_hv_pmos w=4u l=0.45u ng=1 m=2
x2 bias_VN vssa cfringe33x55
x3 bias_VP vdda cfringe34x70
.ends

* expanding   symbol:  MasterBias.sym # of pins=15
** sym_path: /foss/designs/ihp_INI_project/INI_Block/MasterBias.sym
** sch_path: /foss/designs/ihp_INI_project/INI_Block/MasterBias.sch
.subckt MasterBias VBP_TIA BYP_EN VREF_100mV EXT_REF_EN VDDA IREF_1uA IREF_100nA IREF_10nA IREF_1nA IREF_100pA IREF_10pA IREF_1pA
+ IREF_100fA VREG_pad VSSA
*.PININFO IREF_100nA:B IREF_10nA:B IREF_1nA:B IREF_100pA:B IREF_10pA:B IREF_1pA:B IREF_100fA:B VSSA:B IREF_1uA:B VREF_100mV:I
*+ VBP_TIA:I VDDA:B BYP_EN:I EXT_REF_EN:I VREG_pad:B
MMnbias VREG_pad EXT_REF_EN net8 VSSA sg13_hv_nmos w=25u l=500n ng=20
x10 VDDA EXT_REF_ENB EXT_REF_EN VSSA inv_BG
MMnbias1 VSENSE EXT_REF_ENB net8 VSSA sg13_hv_nmos w=25u l=500n ng=20
MMnbias2 net8 VBIAS net9 VSSA sg13_hv_nmos w=25u l=500n ng=20
MMnbias3 net8 BYP_EN net9 VSSA sg13_hv_nmos w=25u l=500n ng=20
x1 VDDA net9 IREF_100nA net2 VSSA DecadeDivider_2
x2 VDDA net3 IREF_1nA net4 VSSA DecadeDivider_2
x3 VDDA net2 IREF_10nA net3 VSSA DecadeDivider_2
x4 VDDA net4 IREF_100pA net5 VSSA DecadeDivider_2
x5 VDDA net5 IREF_10pA net6 VSSA DecadeDivider_2
x6 VDDA net6 IREF_1pA net7 VSSA DecadeDivider_2
x7 VDDA net7 IREF_100fA net1 VSSA DecadeDivider_2
x8 VDDA net9 IREF_1uA VSSA DecadeDividerAux
x9 VDDA VBP_TIA net10 net8 VBIAS VREF_100mV VSSA OTA_bc
x11 VSSA VDDA Cap1
x12 net9 VDDA Cap4
x13 net10 VBIAS Cap5
x14 VSSA VSENSE VSSA reshigh_92k
.ends

* expanding   symbol:  a_buffP.sym # of pins=6
** sym_path: /foss/designs/ihp_INI_project/INI_Block/a_buffP.sym
** sch_path: /foss/designs/ihp_INI_project/INI_Block/a_buffP.sch
.subckt a_buffP vdd vout vinp vinn vbias vss
*.PININFO vinp:I vinn:I vbias:I vdd:B vss:B vout:O
MM3 gate_n_l gate_n_l vss vss sg13_lv_nmos w=2u l=1u ng=2 m=2
MM1 gate_n_l vinn tail vdd sg13_lv_pmos w=4u l=200n ng=4 m=8
MM2 gate_n_r vinp tail vdd sg13_lv_pmos w=4u l=200n ng=4 m=8
MM5 tail net1 vdd vdd sg13_lv_pmos w=2u l=2u ng=2 m=2
MM4 gate_n_r gate_n_r vss vss sg13_lv_nmos w=2u l=1u ng=2 m=2
MM9 gate_p gate_p vdd vdd sg13_lv_pmos w=2u l=1u ng=2 m=2
MM10 vout gate_p vdd vdd sg13_lv_pmos w=2u l=1u ng=2 m=2
MM7 gate_p gate_n_l vss vss sg13_lv_nmos w=2u l=1u ng=2 m=2
MM8 vout gate_n_r vss vss sg13_lv_nmos w=2u l=1u ng=2 m=2
MM6 net1 net1 vdd vdd sg13_lv_pmos w=2u l=2u ng=2 m=2
MM11 net1 vbias vss vss sg13_lv_nmos w=2u l=1u ng=2 m=4
MM12 vdd vdd vdd vdd sg13_lv_pmos w=1u l=1.54u ng=1 m=4
MM13 vdd vdd vdd vdd sg13_lv_pmos w=4u l=0.13u ng=4 m=8
MM14 vss vss vss vss sg13_lv_nmos w=1u l=1u ng=1 m=21
MM16 vdd vdd vdd vdd sg13_lv_pmos w=1u l=0.78u ng=1 m=2
.ends

* expanding   symbol:  FB_system.sym # of pins=4
** sym_path: /foss/designs/ihp_INI_project/INI_Block/FB_system.sym
** sch_path: /foss/designs/ihp_INI_project/INI_Block/FB_system.sch
.subckt FB_system vdda out V_mem vssa
*.PININFO out:O V_mem:B vssa:B vdda:B
MMmirr Vmir Vmir vdda vdda sg13_hv_pmos w=4u l=2u ng=4
MMmirl4 V_mem Vmir net1 vdda sg13_hv_pmos w=1u l=2u ng=1
MMthr out V_mem Vmir vdda sg13_hv_pmos w=4u l=2u ng=4
MMmem1 out V_mem net2 vssa sg13_hv_nmos w=1u l=2u ng=1 m=2
MMmirl3 net1 Vmir net3 vdda sg13_hv_pmos w=1u l=2u ng=1
MMmirl2 net3 Vmir net4 vdda sg13_hv_pmos w=1u l=2u ng=1
MMmirl1 net4 Vmir vdda vdda sg13_hv_pmos w=1u l=2u ng=1
MMmem2 net2 V_mem net5 vssa sg13_hv_nmos w=1u l=2u ng=1 m=2
MMmem3 net5 V_mem net6 vssa sg13_hv_nmos w=1u l=2u ng=1 m=2
MMmem4 net6 V_mem vssa vssa sg13_hv_nmos w=1u l=2u ng=1 m=2
MMdum6 out vdda vdda vdda sg13_hv_pmos w=1u l=2u ng=1 m=2
MMdum7 V_mem vdda vdda vdda sg13_hv_pmos w=1u l=2u ng=1
MMdum1 vssa vssa out vssa sg13_hv_nmos w=2u l=2u ng=2
MMdum2 vssa vssa vssa vssa sg13_hv_nmos w=12u l=2u ng=2
MMdum3 vdda vdda vdda vdda sg13_hv_pmos w=12u l=2u ng=2
.ends

* expanding   symbol:  ADAP_system.sym # of pins=8
** sym_path: /foss/designs/ihp_INI_project/INI_Block/ADAP_system.sym
** sch_path: /foss/designs/ihp_INI_project/INI_Block/ADAP_system.sch
.subckt ADAP_system vdda ackext_VABI DPI_capabias_VP gain_VPI in_UNO DPI_gain_VNI DPI_lk_VNI vssa
*.PININFO ackext_VABI:I gain_VPI:I DPI_gain_VNI:I DPI_lk_VNI:I vssa:B vdda:B DPI_capabias_VP:B in_UNO:B
MM21 net1 gain_VPI net_DM1_SM21 vdda sg13_hv_pmos w=4u l=4u ng=2 m=4
MM18 in_UNO DPI_capabias_VP vssa vssa sg13_hv_nmos w=4u l=4u ng=2 m=4
MM1 net_DM1_SM21 ackext_VABI vdda vdda sg13_hv_pmos w=1.2u l=4u ng=4
Xdpi2 net1 vdda DPI_capabias_VP DPI_gain_VNI vssa DPI_lk_VNI DPI_gain
MMdum5 net_DM1_SM21 vdda vdda vdda sg13_hv_pmos w=2u l=2.75u ng=1 m=4
MMdum1 net_DM1_SM21 vdda vdda vdda sg13_hv_pmos w=0.3u l=2.75u ng=1 m=2
.ends

* expanding   symbol:  REF_system.sym # of pins=7
** sym_path: /foss/designs/ihp_INI_project/INI_Block/REF_system.sym
** sch_path: /foss/designs/ihp_INI_project/INI_Block/REF_system.sch
.subckt REF_system ack_VABI mem_VNO req_VABI capabias_VPN vssa lk_VPI vdda
*.PININFO lk_VPI:I req_VABI:I ack_VABI:I capabias_VPN:B mem_VNO:O vssa:B vdda:B
MM10 capabias_VPN req_VABI net2 vdda sg13_hv_pmos w=1u l=0.5u ng=1
MM11 capabias_VPN req_VABI net1 vssa sg13_hv_nmos w=1u l=0.5u ng=1
MM12 net2 ack_VABI vdda vdda sg13_hv_pmos w=1u l=0.5u ng=1
MM13 mem_VNO capabias_VPN vssa vssa sg13_hv_nmos w=1u l=0.5u ng=1
MM14 net1 lk_VPI vssa vssa sg13_hv_nmos w=4u l=4u ng=2 m=4
.ends

* expanding   symbol:  pulse_extender_V2.sym # of pins=6
** sym_path: /foss/designs/ihp_INI_project/INI_Block/pulse_extender_V2.sym
** sch_path: /foss/designs/ihp_INI_project/INI_Block/pulse_extender_V2.sch
.subckt pulse_extender_V2 vdda vssa out_VAO in_VAI pwbias_VPI capa_VP
*.PININFO out_VAO:O pwbias_VPI:I in_VAI:I capa_VP:B vssa:B vdda:B
MMp1 out_VAO capa_VP vdda vdda sg13_hv_pmos w=4u l=2u ng=4
MMn1 out_VAO capa_VP vssa vssa sg13_hv_nmos w=4u l=2u ng=4
MMn4 capa_VP in_VAI vssa vssa sg13_hv_nmos w=4u l=2u ng=4
MMstarve4 capa_VP pwbias_VPI vdda vdda sg13_hv_pmos w=4u l=2u ng=4
MMp3 capa_VP out_VAO vdda vdda sg13_hv_pmos w=4u l=2u ng=4
MMdum2 vssa vssa vssa vssa sg13_hv_nmos w=12u l=2u ng=2
MMdum1 vdda vdda vdda vdda sg13_hv_pmos w=12u l=2u ng=2
.ends

* expanding   symbol:  inv.sym # of pins=4
** sym_path: /foss/designs/ihp_INI_project/INI_Block/inv.sym
** sch_path: /foss/designs/ihp_INI_project/INI_Block/inv.sch
.subckt inv vdda out in vssa
*.PININFO in:I out:O vssa:B vdda:B
MM1 out in vdda vdda sg13_hv_pmos w=4u l=0.5u ng=1
MM2 out in vssa vssa sg13_hv_nmos w=4u l=0.5u ng=1
.ends

* expanding   symbol:  inv_hc.sym # of pins=4
** sym_path: /foss/designs/ihp_INI_project/INI_Block/inv_hc.sym
** sch_path: /foss/designs/ihp_INI_project/INI_Block/inv_hc.sch
.subckt inv_hc vdda out in vssa
*.PININFO in:I out:O vssa:B vdda:B
MM1 out in vdda vdda sg13_hv_pmos w=10u l=0.5u ng=2
MM2 out in vssa vssa sg13_hv_nmos w=10u l=0.5u ng=2
.ends

* expanding   symbol:  DPI_gain.sym # of pins=6
** sym_path: /foss/designs/ihp_INI_project/INI_Block/DPI_gain.sym
** sch_path: /foss/designs/ihp_INI_project/INI_Block/DPI_gain.sch
.subckt DPI_gain in_UI vdda capabias_VPN gain_VNI vssa lk_VNI
*.PININFO gain_VNI:I lk_VNI:I capabias_VPN:B vssa:B vdda:B in_UI:B
MMdifl vssa gain_VNI in_UI vdda sg13_hv_pmos w=2u l=2u ng=2 m=8
MMdifr capabias_VPN capabias_VPN in_UI vdda sg13_hv_pmos w=2u l=2u ng=2 m=8
MMtau capabias_VPN lk_VNI vssa vssa sg13_hv_nmos w=4u l=4u ng=2 m=4
MMdum2 in_UI vdda vdda vdda sg13_hv_pmos w=1u l=2u ng=1 m=8
MM2 vdda vdda vdda vdda sg13_hv_pmos w=10u l=2u ng=1
.ends

* expanding   symbol:  cfringe60x8.sym # of pins=2
** sym_path: /foss/designs/ihp_INI_project/INI_Block/cfringe60x8.sym
** sch_path: /foss/designs/ihp_INI_project/INI_Block/cfringe60x8.sch
.subckt cfringe60x8 C2 C1
*.PININFO C1:B C2:B
CC1 C1 C2 cap_mfringe w=60.0u l=8.0u mmin=1 mmax=4
.ends

* expanding   symbol:  cfringe35x8.sym # of pins=2
** sym_path: /foss/designs/ihp_INI_project/INI_Block/cfringe35x8.sym
** sch_path: /foss/designs/ihp_INI_project/INI_Block/cfringe35x8.sch
.subckt cfringe35x8 C2 C1
*.PININFO C1:B C2:B
CC1 C1 C2 cap_mfringe w=35.0u l=8.0u mmin=1 mmax=4
.ends

* expanding   symbol:  cfringe6x3.sym # of pins=2
** sym_path: /foss/designs/ihp_INI_project/INI_Block/cfringe6x3.sym
** sch_path: /foss/designs/ihp_INI_project/INI_Block/cfringe6x3.sch
.subckt cfringe6x3 C2 C1
*.PININFO C1:B C2:B
CC1 C1 C2 cap_mfringe w=6.0u l=3.0u mmin=1 mmax=4
.ends

* expanding   symbol:  inv_BG.sym # of pins=4
** sym_path: /foss/designs/ihp_INI_project/INI_Block/inv_BG.sym
** sch_path: /foss/designs/ihp_INI_project/INI_Block/inv_BG.sch
.subckt inv_BG vdda out in vssa
*.PININFO in:I out:O vssa:B vdda:B
MM1 out in vdda vdda sg13_hv_pmos w=1u l=0.5u ng=1
MM2 out in vssa vssa sg13_hv_nmos w=1u l=0.5u ng=1
.ends

* expanding   symbol:  SelMUX.sym # of pins=5
** sym_path: /foss/designs/ihp_INI_project/INI_Block/SelMUX.sym
** sch_path: /foss/designs/ihp_INI_project/INI_Block/SelMUX.sch
.subckt SelMUX MASTER_bias_VN[7] MASTER_bias_VN[6] MASTER_bias_VN[5] MASTER_bias_VN[4] MASTER_bias_VN[3] MASTER_bias_VN[2]
+ MASTER_bias_VN[1] MASTER_bias_VN[0] vssa en_VS[10] en_VS[9] en_VS[8] en_VSB[10] en_VSB[9] en_VSB[8] MASTER_biasout_VN
*.PININFO MASTER_bias_VN[7:0]:I MASTER_biasout_VN:O en_VS[10:8]:I en_VSB[10:8]:I vssa:B
MMUX_L0_0 MASTER_bias_VN[7] en_VS[8] net1 vssa sg13_hv_nmos w=4.98u l=0.45u ng=6
MMUX_L0_1 MASTER_bias_VN[6] en_VSB[8] net1 vssa sg13_hv_nmos w=0.45u l=10u ng=1
MMUX_L0_2 MASTER_bias_VN[5] en_VS[8] net2 vssa sg13_hv_nmos w=0.45u l=10u ng=1
MMUX_L0_3 MASTER_bias_VN[4] en_VSB[8] net2 vssa sg13_hv_nmos w=0.45u l=10u ng=1
MMUX_L0_4 MASTER_bias_VN[3] en_VS[8] net3 vssa sg13_hv_nmos w=0.45u l=10u ng=1
MMUX_L0_5 MASTER_bias_VN[2] en_VSB[8] net3 vssa sg13_hv_nmos w=0.45u l=10u ng=1
MMUX_L0_6 MASTER_bias_VN[1] en_VS[8] net4 vssa sg13_hv_nmos w=0.45u l=10u ng=1
MMUX_L0_7 MASTER_bias_VN[0] en_VSB[8] net4 vssa sg13_hv_nmos w=0.45u l=10u ng=1
MMUX_L1_A net1 en_VS[9] net5 vssa sg13_hv_nmos w=4.98u l=0.45u ng=6
MMUX_L1_B net2 en_VSB[9] net5 vssa sg13_hv_nmos w=0.45u l=10u ng=1
MMUX_L1_C net3 en_VS[9] net6 vssa sg13_hv_nmos w=0.45u l=10u ng=1
MMUX_L1_D net4 en_VSB[9] net6 vssa sg13_hv_nmos w=0.45u l=10u ng=1
MMUX_L2_A net5 en_VS[10] MASTER_biasout_VN vssa sg13_hv_nmos w=5u l=0.45u ng=2
MMUX_L2_B net6 en_VSB[10] MASTER_biasout_VN vssa sg13_hv_nmos w=0.45u l=10u ng=1
.ends

* expanding   symbol:  ISINK.sym # of pins=5
** sym_path: /foss/designs/ihp_INI_project/INI_Block/ISINK.sym
** sch_path: /foss/designs/ihp_INI_project/INI_Block/ISINK.sch
.subckt ISINK bias_VN vssa en_VS io_UN bulk
*.PININFO en_VS:I vssa:B bias_VN:I io_UN:B bulk:B
MM1 io_UN en_VS net2 bulk sg13_hv_nmos w=2.5u l=0.5u ng=1
MM2 net2 bias_VN net1 bulk sg13_hv_nmos w=1u l=4u ng=1
MM3 net1 bias_VN vssa bulk sg13_hv_nmos w=1u l=4u ng=1
.ends

* expanding   symbol:  SplitterCell.sym # of pins=9
** sym_path: /foss/designs/ihp_INI_project/INI_Block/SplitterCell.sym
** sch_path: /foss/designs/ihp_INI_project/INI_Block/SplitterCell.sch
.subckt SplitterCell en_VS A_UN B_UN en_VSB bias_VN vssa out_UPB out_UP
*.PININFO en_VS:I en_VSB:I bias_VN:I B_UN:B out_UP:B out_UPB:B vssa:B A_UN:B
MM_en out_UP en_VS net1 vssa sg13_hv_nmos w=1u l=1u ng=1
MM_enb out_UPB en_VSB net1 vssa sg13_hv_nmos w=1u l=1u ng=1
MM_s1 net1 bias_VN net3 vssa sg13_hv_nmos w=2u l=10u ng=1
MM_s2 net3 bias_VN net4 vssa sg13_hv_nmos w=2u l=10u ng=1
MM_s3 net4 bias_VN net5 vssa sg13_hv_nmos w=2u l=10u ng=1
MM_s4 net5 bias_VN net2 vssa sg13_hv_nmos w=2u l=10u ng=1
MM_s5 net2 bias_VN net6 vssa sg13_hv_nmos w=2u l=10u ng=1
MM_s6 net6 bias_VN net7 vssa sg13_hv_nmos w=2u l=10u ng=1
MM_s7 net7 bias_VN net8 vssa sg13_hv_nmos w=2u l=10u ng=1
MM_s8 net8 bias_VN A_UN vssa sg13_hv_nmos w=2u l=10u ng=1
MM_s9 A_UN bias_VN net9 vssa sg13_hv_nmos w=2u l=10u ng=1
MM_s10 net9 bias_VN net10 vssa sg13_hv_nmos w=2u l=10u ng=1
MM_s11 net10 bias_VN net11 vssa sg13_hv_nmos w=2u l=10u ng=1
MM_s12 net11 bias_VN B_UN vssa sg13_hv_nmos w=2u l=10u ng=1
.ends

* expanding   symbol:  cfringe34x70.sym # of pins=2
** sym_path: /foss/designs/ihp_INI_project/INI_Block/cfringe34x70.sym
** sch_path: /foss/designs/ihp_INI_project/INI_Block/cfringe34x70.sch
.subckt cfringe34x70 C2 C1
*.PININFO C1:B C2:B
CC3 C1 C2 cap_mfringe w=9.3750u l=22.5u mmin=1 mmax=4
CC1 C2 C1 cap_mfringe w=9.3750u l=11.26u mmin=1 mmax=4
CC4 C2 C1 cap_mfringe w=15u l=36.5u mmin=1 mmax=4
.ends

* expanding   symbol:  cfringe33x55.sym # of pins=2
** sym_path: /foss/designs/ihp_INI_project/INI_Block/cfringe33x55.sym
** sch_path: /foss/designs/ihp_INI_project/INI_Block/cfringe33x55.sch
.subckt cfringe33x55 C2 C1
*.PININFO C2:B C1:B
CC2 C2 C1 cap_mfringe w=4.44u l=5u mmin=1 mmax=4
CC5 C1 C2 cap_mfringe w=8.96u l=19.18u mmin=1 mmax=4
CC6 C1 C2 cap_mfringe w=19.73u l=31u mmin=1 mmax=4
.ends

* expanding   symbol:  cfringe140x6.sym # of pins=2
** sym_path: /foss/designs/ihp_INI_project/INI_Block/cfringe140x6.sym
** sch_path: /foss/designs/ihp_INI_project/INI_Block/cfringe140x6.sch
.subckt cfringe140x6 C2 C1
*.PININFO C1:B C2:B
CC1 C1 C2 cap_mfringe w=140.0u l=6.37u mmin=1 mmax=4
.ends

* expanding   symbol:  DecadeDivider_2.sym # of pins=5
** sym_path: /foss/designs/ihp_INI_project/INI_Block/DecadeDivider_2.sym
** sch_path: /foss/designs/ihp_INI_project/INI_Block/DecadeDivider_2.sch
.subckt DecadeDivider_2 VDDA IREF IREF_CORE[0] IOUT VSSA
*.PININFO VSSA:B VDDA:B IREF:B IREF_CORE[0]:B IOUT:B
x1[2] VDDA IREF VDDA IREF VSSA IREF_CORE[0] ISOURCE
x1[1] VDDA IREF VDDA IREF VSSA IREF_CORE[0] ISOURCE
x10[2] VDDA IREF VDDA IREF VSSA Vbn ISOURCE
x10[1] VDDA IREF VDDA IREF VSSA Vbn ISOURCE
x11[20] VDDA IREF VDDA IREF VSSA IREF ISOURCE
x11[19] VDDA IREF VDDA IREF VSSA IREF ISOURCE
x11[18] VDDA IREF VDDA IREF VSSA IREF ISOURCE
x11[17] VDDA IREF VDDA IREF VSSA IREF ISOURCE
x11[16] VDDA IREF VDDA IREF VSSA IREF ISOURCE
x11[15] VDDA IREF VDDA IREF VSSA IREF ISOURCE
x11[14] VDDA IREF VDDA IREF VSSA IREF ISOURCE
x11[13] VDDA IREF VDDA IREF VSSA IREF ISOURCE
x11[12] VDDA IREF VDDA IREF VSSA IREF ISOURCE
x11[11] VDDA IREF VDDA IREF VSSA IREF ISOURCE
x11[10] VDDA IREF VDDA IREF VSSA IREF ISOURCE
x11[9] VDDA IREF VDDA IREF VSSA IREF ISOURCE
x11[8] VDDA IREF VDDA IREF VSSA IREF ISOURCE
x11[7] VDDA IREF VDDA IREF VSSA IREF ISOURCE
x11[6] VDDA IREF VDDA IREF VSSA IREF ISOURCE
x11[5] VDDA IREF VDDA IREF VSSA IREF ISOURCE
x11[4] VDDA IREF VDDA IREF VSSA IREF ISOURCE
x11[3] VDDA IREF VDDA IREF VSSA IREF ISOURCE
x11[2] VDDA IREF VDDA IREF VSSA IREF ISOURCE
x11[1] VDDA IREF VDDA IREF VSSA IREF ISOURCE
x3[15] IOUT VSSA Vbn Vbn VSSA ISINK_MB
x3[14] IOUT VSSA Vbn Vbn VSSA ISINK_MB
x3[13] IOUT VSSA Vbn Vbn VSSA ISINK_MB
x3[12] IOUT VSSA Vbn Vbn VSSA ISINK_MB
x3[11] IOUT VSSA Vbn Vbn VSSA ISINK_MB
x3[10] IOUT VSSA Vbn Vbn VSSA ISINK_MB
x3[9] IOUT VSSA Vbn Vbn VSSA ISINK_MB
x3[8] IOUT VSSA Vbn Vbn VSSA ISINK_MB
x3[7] IOUT VSSA Vbn Vbn VSSA ISINK_MB
x3[6] IOUT VSSA Vbn Vbn VSSA ISINK_MB
x3[5] IOUT VSSA Vbn Vbn VSSA ISINK_MB
x3[4] IOUT VSSA Vbn Vbn VSSA ISINK_MB
x3[3] IOUT VSSA Vbn Vbn VSSA ISINK_MB
x3[2] IOUT VSSA Vbn Vbn VSSA ISINK_MB
x3[1] IOUT VSSA Vbn Vbn VSSA ISINK_MB
x2[15] Vbn VSSA Vbn Vbn VSSA ISINK_MB
x2[14] Vbn VSSA Vbn Vbn VSSA ISINK_MB
x2[13] Vbn VSSA Vbn Vbn VSSA ISINK_MB
x2[12] Vbn VSSA Vbn Vbn VSSA ISINK_MB
x2[11] Vbn VSSA Vbn Vbn VSSA ISINK_MB
x2[10] Vbn VSSA Vbn Vbn VSSA ISINK_MB
x2[9] Vbn VSSA Vbn Vbn VSSA ISINK_MB
x2[8] Vbn VSSA Vbn Vbn VSSA ISINK_MB
x2[7] Vbn VSSA Vbn Vbn VSSA ISINK_MB
x2[6] Vbn VSSA Vbn Vbn VSSA ISINK_MB
x2[5] Vbn VSSA Vbn Vbn VSSA ISINK_MB
x2[4] Vbn VSSA Vbn Vbn VSSA ISINK_MB
x2[3] Vbn VSSA Vbn Vbn VSSA ISINK_MB
x2[2] Vbn VSSA Vbn Vbn VSSA ISINK_MB
x2[1] Vbn VSSA Vbn Vbn VSSA ISINK_MB
x1 VDDA IREF Cap3
.ends

* expanding   symbol:  DecadeDividerAux.sym # of pins=4
** sym_path: /foss/designs/ihp_INI_project/INI_Block/DecadeDividerAux.sym
** sch_path: /foss/designs/ihp_INI_project/INI_Block/DecadeDividerAux.sch
.subckt DecadeDividerAux VDDA VBIAS IREF_CORE[0] VSSA
*.PININFO VSSA:B VDDA:B VBIAS:B IREF_CORE[0]:B
x1[20] VDDA VBIAS VDDA VBIAS VSSA IREF_CORE[0] ISOURCE
x1[19] VDDA VBIAS VDDA VBIAS VSSA IREF_CORE[0] ISOURCE
x1[18] VDDA VBIAS VDDA VBIAS VSSA IREF_CORE[0] ISOURCE
x1[17] VDDA VBIAS VDDA VBIAS VSSA IREF_CORE[0] ISOURCE
x1[16] VDDA VBIAS VDDA VBIAS VSSA IREF_CORE[0] ISOURCE
x1[15] VDDA VBIAS VDDA VBIAS VSSA IREF_CORE[0] ISOURCE
x1[14] VDDA VBIAS VDDA VBIAS VSSA IREF_CORE[0] ISOURCE
x1[13] VDDA VBIAS VDDA VBIAS VSSA IREF_CORE[0] ISOURCE
x1[12] VDDA VBIAS VDDA VBIAS VSSA IREF_CORE[0] ISOURCE
x1[11] VDDA VBIAS VDDA VBIAS VSSA IREF_CORE[0] ISOURCE
x1[10] VDDA VBIAS VDDA VBIAS VSSA IREF_CORE[0] ISOURCE
x1[9] VDDA VBIAS VDDA VBIAS VSSA IREF_CORE[0] ISOURCE
x1[8] VDDA VBIAS VDDA VBIAS VSSA IREF_CORE[0] ISOURCE
x1[7] VDDA VBIAS VDDA VBIAS VSSA IREF_CORE[0] ISOURCE
x1[6] VDDA VBIAS VDDA VBIAS VSSA IREF_CORE[0] ISOURCE
x1[5] VDDA VBIAS VDDA VBIAS VSSA IREF_CORE[0] ISOURCE
x1[4] VDDA VBIAS VDDA VBIAS VSSA IREF_CORE[0] ISOURCE
x1[3] VDDA VBIAS VDDA VBIAS VSSA IREF_CORE[0] ISOURCE
x1[2] VDDA VBIAS VDDA VBIAS VSSA IREF_CORE[0] ISOURCE
x1[1] VDDA VBIAS VDDA VBIAS VSSA IREF_CORE[0] ISOURCE
MM1 VDDA VDDA VDDA VDDA sg13_hv_pmos w=0.3u l=5u ng=1 m=2
.ends

* expanding   symbol:  OTA_bc.sym # of pins=7
** sym_path: /foss/designs/ihp_INI_project/INI_Block/OTA_bc.sym
** sch_path: /foss/designs/ihp_INI_project/INI_Block/OTA_bc.sch
.subckt OTA_bc VDDA VBP C_p1 INN VOP INP VSSA
*.PININFO VBP:I INP:I INN:I VSSA:B VDDA:B VOP:O C_p1:I
MM13 n1 n1 VSSA VSSA sg13_hv_nmos w=2u l=0.5u ng=2 m=2
MM1 n2 n2 VSSA VSSA sg13_hv_nmos w=2u l=0.5u ng=2 m=2
MM12 n1 INN vtail VDDA sg13_hv_pmos w=16u l=0.5u ng=2 m=4
MM3 n2 INP vtail VDDA sg13_hv_pmos w=16u l=0.5u ng=2 m=4
MM4 vtail VBP VDDA VDDA sg13_hv_pmos w=12u l=500n ng=2 m=8
MM5 vpmirr vpmirr VDDA VDDA sg13_hv_pmos w=2u l=500n ng=2 m=4
MM6 vout1stage vpmirr VDDA VDDA sg13_hv_pmos w=2u l=500n ng=2 m=4
MM7 vout1stage n1 VSSA VSSA sg13_hv_nmos w=1.75u l=0.5u ng=2 m=4
MM8 VOP vout1stage VSSA VSSA sg13_hv_nmos w=4u l=0.5u ng=4 m=4
MM9 VOP VBP VDDA VDDA sg13_hv_pmos w=4u l=0.5u ng=2
MM10 vpmirr n2 VSSA VSSA sg13_hv_nmos w=2u l=0.5u ng=2 m=4
x1 C_p1 vout1stage VSSA reshigh_50k
.ends

* expanding   symbol:  Cap1.sym # of pins=2
** sym_path: /foss/designs/ihp_INI_project/INI_Block/Cap1.sym
** sch_path: /foss/designs/ihp_INI_project/INI_Block/Cap1.sch
.subckt Cap1 Cp1 Cp2
*.PININFO Cp2:B Cp1:B
CC1 Cp1 Cp2 cap_mfringe w=407.0u l=35.0u mmin=1 mmax=4
.ends

* expanding   symbol:  Cap4.sym # of pins=2
** sym_path: /foss/designs/ihp_INI_project/INI_Block/Cap4.sym
** sch_path: /foss/designs/ihp_INI_project/INI_Block/Cap4.sch
.subckt Cap4 Cp1 Cp2
*.PININFO Cp2:B Cp1:B
CC11 Cp1 Cp2 cap_mfringe w=60.0u l=30.0u mmin=1 mmax=4
.ends

* expanding   symbol:  Cap5.sym # of pins=2
** sym_path: /foss/designs/ihp_INI_project/INI_Block/Cap5.sym
** sch_path: /foss/designs/ihp_INI_project/INI_Block/Cap5.sch
.subckt Cap5 Cp1 Cp2
*.PININFO Cp2:B Cp1:B
CC3 Cp2 Cp1 cap_mfringe w=28.0u l=10.0u mmin=1 mmax=4
.ends

* expanding   symbol:  reshigh_92k.sym # of pins=3
** sym_path: /foss/designs/ihp_INI_project/INI_Block/reshigh_92k.sym
** sch_path: /foss/designs/ihp_INI_project/INI_Block/reshigh_92k.sch
.subckt reshigh_92k R1 R2 VSSA
*.PININFO R2:B R1:B VSSA:B
RR3 R1 R2 91.97k $SUB=VSSA $[rhigh] w=0.5e-6 l=31e-6 b=0
.ends

* expanding   symbol:  ISOURCE.sym # of pins=6
** sym_path: /foss/designs/ihp_INI_project/INI_Block/ISOURCE.sym
** sch_path: /foss/designs/ihp_INI_project/INI_Block/ISOURCE.sch
.subckt ISOURCE VDDA MBIAS bulk ENB VSSA IO
*.PININFO VDDA:B MBIAS:I ENB:I IO:B VSSA:B bulk:B
MM2 net1 MBIAS VDDA bulk sg13_hv_pmos w=1u l=5u ng=1
MM1 IO ENB net1 bulk sg13_hv_pmos w=3.3u l=0.5u ng=2
.ends

* expanding   symbol:  ISINK_MB.sym # of pins=5
** sym_path: /foss/designs/ihp_INI_project/INI_Block/ISINK_MB.sym
** sch_path: /foss/designs/ihp_INI_project/INI_Block/ISINK_MB.sch
.subckt ISINK_MB IO bulk EN MBIAS VSSA
*.PININFO MBIAS:I EN:I IO:B VSSA:B bulk:B
MM1 IO EN net2 bulk sg13_hv_nmos w=2.5u l=0.5u ng=1
MM2 net2 MBIAS net1 bulk sg13_hv_nmos w=1u l=2u ng=1
MM3 net1 MBIAS VSSA bulk sg13_hv_nmos w=1u l=2u ng=1
.ends

* expanding   symbol:  Cap3.sym # of pins=2
** sym_path: /foss/designs/ihp_INI_project/INI_Block/Cap3.sym
** sch_path: /foss/designs/ihp_INI_project/INI_Block/Cap3.sch
.subckt Cap3 Cp1 Cp2
*.PININFO Cp2:B Cp1:B
CC4 Cp1 Cp2 cap_mfringe w=14.0u l=88.0u mmin=1 mmax=4
.ends

* expanding   symbol:  reshigh_50k.sym # of pins=3
** sym_path: /foss/designs/ihp_INI_project/INI_Block/reshigh_50k.sym
** sch_path: /foss/designs/ihp_INI_project/INI_Block/reshigh_50k.sch
.subckt reshigh_50k R1 R2 VSSA
*.PININFO R2:B R1:B VSSA:B
RR1 R2 R1 49.84k $SUB=VSSA $[rhigh] w=0.5e-6 l=16.75e-6 b=0
.ends
